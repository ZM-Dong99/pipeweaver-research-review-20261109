.SUBCKT sky130_fd_sc_hd__a21o_1 A1 A2 B1 VGND VNB VPB VPWR X
*.PININFO A1:I A2:I B1:I VGND:I VNB:I VPB:I VPWR:I X:O
MMPA0 pndA A1 VPWR VPB pfet_01v8_hvt m=1 w=1.0 l=0.15 mult=1 sa=0.265
+ sb=0.265 sd=0.28 topography=normal area=0.063 perim=1.14
MMPA1 pndA A2 VPWR VPB pfet_01v8_hvt m=1 w=1.0 l=0.15 mult=1 sa=0.265
+ sb=0.265 sd=0.28 topography=normal area=0.063 perim=1.14
MMPB0 y B1 pndA VPB pfet_01v8_hvt m=1 w=1.0 l=0.15 mult=1 sa=0.265
+ sb=0.265 sd=0.28 topography=normal area=0.063 perim=1.14
MMIPX X y VPWR VPB pfet_01v8_hvt m=1 w=1.0 l=0.15 mult=1 sa=0.265
+ sb=0.265 sd=0.28 topography=normal area=0.063 perim=1.14
MMNA0 y A1 sndA1 VNB nfet_01v8 m=1 w=0.65 l=0.15 mult=1 sa=0.265
+ sb=0.265 sd=0.28 topography=normal area=0.063 perim=1.14
MMNA1 sndA1 A2 VGND VNB nfet_01v8 m=1 w=0.65 l=0.15 mult=1 sa=0.265
+ sb=0.265 sd=0.28 topography=normal area=0.063 perim=1.14
MMNB0 y B1 VGND VNB nfet_01v8 m=1 w=0.65 l=0.15 mult=1 sa=0.265
+ sb=0.265 sd=0.28 topography=normal area=0.063 perim=1.14
MMINX X y VGND VNB nfet_01v8 m=1 w=0.65 l=0.15 mult=1 sa=0.265
+ sb=0.265 sd=0.28 topography=normal area=0.063 perim=1.14
.ENDS sky130_fd_sc_hd__a21o_1

.SUBCKT sky130_fd_sc_hd__a21oi_1 A1 A2 B1 VGND VNB VPB VPWR Y
*.PININFO A1:I A2:I B1:I VGND:I VNB:I VPB:I VPWR:I Y:O
MMPA0 pndA A1 VPWR VPB pfet_01v8_hvt m=1 w=1.0 l=0.15 mult=1 sa=0.265
+ sb=0.265 sd=0.28 topography=normal area=0.063 perim=1.14
MMPA1 pndA A2 VPWR VPB pfet_01v8_hvt m=1 w=1.0 l=0.15 mult=1 sa=0.265
+ sb=0.265 sd=0.28 topography=normal area=0.063 perim=1.14
MMPB0 Y B1 pndA VPB pfet_01v8_hvt m=1 w=1.0 l=0.15 mult=1 sa=0.265
+ sb=0.265 sd=0.28 topography=normal area=0.063 perim=1.14
MMNA0 Y A1 sndA1 VNB nfet_01v8 m=1 w=0.65 l=0.15 mult=1 sa=0.265
+ sb=0.265 sd=0.28 topography=normal area=0.063 perim=1.14
MMNA1 sndA1 A2 VGND VNB nfet_01v8 m=1 w=0.65 l=0.15 mult=1 sa=0.265
+ sb=0.265 sd=0.28 topography=normal area=0.063 perim=1.14
MMNB0 Y B1 VGND VNB nfet_01v8 m=1 w=0.65 l=0.15 mult=1 sa=0.265
+ sb=0.265 sd=0.28 topography=normal area=0.063 perim=1.14
.ENDS sky130_fd_sc_hd__a21oi_1

.SUBCKT sky130_fd_sc_hd__a21oi_2 A1 A2 B1 VGND VNB VPB VPWR Y
*.PININFO A1:I A2:I B1:I VGND:I VNB:I VPB:I VPWR:I Y:O
MMPA0 pndA A1 VPWR VPB pfet_01v8_hvt m=2 w=1.0 l=0.15 mult=1 sa=0.265
+ sb=0.265 sd=0.28 topography=normal area=0.063 perim=1.14
MMPA1 pndA A2 VPWR VPB pfet_01v8_hvt m=2 w=1.0 l=0.15 mult=1 sa=0.265
+ sb=0.265 sd=0.28 topography=normal area=0.063 perim=1.14
MMPB0 Y B1 pndA VPB pfet_01v8_hvt m=2 w=1.0 l=0.15 mult=1 sa=0.265
+ sb=0.265 sd=0.28 topography=normal area=0.063 perim=1.14
MMNA0 Y A1 sndA1 VNB nfet_01v8 m=2 w=0.65 l=0.15 mult=1 sa=0.265
+ sb=0.265 sd=0.28 topography=normal area=0.063 perim=1.14
MMNA1 sndA1 A2 VGND VNB nfet_01v8 m=2 w=0.65 l=0.15 mult=1 sa=0.265
+ sb=0.265 sd=0.28 topography=normal area=0.063 perim=1.14
MMNB0 Y B1 VGND VNB nfet_01v8 m=2 w=0.65 l=0.15 mult=1 sa=0.265
+ sb=0.265 sd=0.28 topography=normal area=0.063 perim=1.14
.ENDS sky130_fd_sc_hd__a21oi_2

.SUBCKT sky130_fd_sc_hd__and2_1 A B VGND VNB VPB VPWR X
*.PININFO A:I B:I VGND:I VNB:I VPB:I VPWR:I X:O
MMP0 y A VPWR VPB pfet_01v8_hvt m=1 w=0.42 l=0.15 mult=1 sa=0.265
+ sb=0.265 sd=0.28 topography=normal area=0.063 perim=1.14
MMP1 y B VPWR VPB pfet_01v8_hvt m=1 w=0.42 l=0.15 mult=1 sa=0.265
+ sb=0.265 sd=0.28 topography=normal area=0.063 perim=1.14
MMIP0 X y VPWR VPB pfet_01v8_hvt m=1 w=1.0 l=0.15 mult=1 sa=0.265
+ sb=0.265 sd=0.28 topography=normal area=0.063 perim=1.14
MMN0 y A sndA VNB nfet_01v8 m=1 w=0.42 l=0.15 mult=1 sa=0.265 sb=0.265
+ sd=0.28 topography=normal area=0.063 perim=1.14
MMN1 sndA B VGND VNB nfet_01v8 m=1 w=0.42 l=0.15 mult=1 sa=0.265
+ sb=0.265 sd=0.28 topography=normal area=0.063 perim=1.14
MMIN0 X y VGND VNB nfet_01v8 m=1 w=0.65 l=0.15 mult=1 sa=0.265
+ sb=0.265 sd=0.28 topography=normal area=0.063 perim=1.14
.ENDS sky130_fd_sc_hd__and2_1

.SUBCKT sky130_fd_sc_hd__and3_1 A B C VGND VNB VPB VPWR X
*.PININFO A:I B:I C:I VGND:I VNB:I VPB:I VPWR:I X:O
MMP0 y A VPWR VPB pfet_01v8_hvt m=1 w=0.42 l=0.15 mult=1 sa=0.265
+ sb=0.265 sd=0.28 topography=normal area=0.063 perim=1.14
MMP1 y B VPWR VPB pfet_01v8_hvt m=1 w=0.42 l=0.15 mult=1 sa=0.265
+ sb=0.265 sd=0.28 topography=normal area=0.063 perim=1.14
MMP2 y C VPWR VPB pfet_01v8_hvt m=1 w=0.42 l=0.15 mult=1 sa=0.265
+ sb=0.265 sd=0.28 topography=normal area=0.063 perim=1.14
MMIP0 X y VPWR VPB pfet_01v8_hvt m=1 w=1.0 l=0.15 mult=1 sa=0.265
+ sb=0.265 sd=0.28 topography=normal area=0.063 perim=1.14
MMN0 y A sndA VNB nfet_01v8 m=1 w=0.42 l=0.15 mult=1 sa=0.265 sb=0.265
+ sd=0.28 topography=normal area=0.063 perim=1.14
MMN1 sndA B sndB VNB nfet_01v8 m=1 w=0.42 l=0.15 mult=1 sa=0.265
+ sb=0.265 sd=0.28 topography=normal area=0.063 perim=1.14
MMN2 sndB C VGND VNB nfet_01v8 m=1 w=0.42 l=0.15 mult=1 sa=0.265
+ sb=0.265 sd=0.28 topography=normal area=0.063 perim=1.14
MMIN0 X y VGND VNB nfet_01v8 m=1 w=0.65 l=0.15 mult=1 sa=0.265
+ sb=0.265 sd=0.28 topography=normal area=0.063 perim=1.14
.ENDS sky130_fd_sc_hd__and3_1

.SUBCKT sky130_fd_sc_hd__buf_1 A VGND VNB VPB VPWR X
*.PININFO A:I VGND:I VNB:I VPB:I VPWR:I X:O
MMIN1 Ab A VGND VNB nfet_01v8 m=1 w=0.52 l=0.15 mult=1 sa=0.265
+ sb=0.265 sd=0.28 topography=normal area=0.063 perim=1.14
MMIN2 X Ab VGND VNB nfet_01v8 m=1 w=0.52 l=0.15 mult=1 sa=0.265
+ sb=0.265 sd=0.28 topography=normal area=0.063 perim=1.14
MMIP1 Ab A VPWR VPB pfet_01v8_hvt m=1 w=0.79 l=0.15 mult=1 sa=0.265
+ sb=0.265 sd=0.28 topography=normal area=0.063 perim=1.14
MMIP2 X Ab VPWR VPB pfet_01v8_hvt m=1 w=0.79 l=0.15 mult=1 sa=0.265
+ sb=0.265 sd=0.28 topography=normal area=0.063 perim=1.14
.ENDS sky130_fd_sc_hd__buf_1

.SUBCKT sky130_fd_sc_hd__buf_2 A VGND VNB VPB VPWR X
*.PININFO A:I VGND:I VNB:I VPB:I VPWR:I X:O
MMIN1 Ab A VGND VNB nfet_01v8 m=1 w=0.42 l=0.15 mult=1 sa=0.265
+ sb=0.265 sd=0.28 topography=normal area=0.063 perim=1.14
MMIN2 X Ab VGND VNB nfet_01v8 m=2 w=0.65 l=0.15 mult=1 sa=0.265
+ sb=0.265 sd=0.28 topography=normal area=0.063 perim=1.14
MMIP1 Ab A VPWR VPB pfet_01v8_hvt m=1 w=0.64 l=0.15 mult=1 sa=0.265
+ sb=0.265 sd=0.28 topography=normal area=0.063 perim=1.14
MMIP2 X Ab VPWR VPB pfet_01v8_hvt m=2 w=1.0 l=0.15 mult=1 sa=0.265
+ sb=0.265 sd=0.28 topography=normal area=0.063 perim=1.14
.ENDS sky130_fd_sc_hd__buf_2

.SUBCKT sky130_fd_sc_hd__buf_4 A VGND VNB VPB VPWR X
*.PININFO A:I VGND:I VNB:I VPB:I VPWR:I X:O
MMIN1 Ab A VGND VNB nfet_01v8 m=1 w=0.65 l=0.15 mult=1 sa=0.265
+ sb=0.265 sd=0.28 topography=normal area=0.063 perim=1.14
MMIN2 X Ab VGND VNB nfet_01v8 m=4 w=0.65 l=0.15 mult=1 sa=0.265
+ sb=0.265 sd=0.28 topography=normal area=0.063 perim=1.14
MMIP1 Ab A VPWR VPB pfet_01v8_hvt m=1 w=1.0 l=0.15 mult=1 sa=0.265
+ sb=0.265 sd=0.28 topography=normal area=0.063 perim=1.14
MMIP2 X Ab VPWR VPB pfet_01v8_hvt m=4 w=1.0 l=0.15 mult=1 sa=0.265
+ sb=0.265 sd=0.28 topography=normal area=0.063 perim=1.14
.ENDS sky130_fd_sc_hd__buf_4

.SUBCKT sky130_fd_sc_hd__buf_6 A VGND VNB VPB VPWR X
*.PININFO A:I VGND:I VNB:I VPB:I VPWR:I X:O
MMIN1 Ab A VGND VNB nfet_01v8 m=2 w=0.65 l=0.15 mult=1 sa=0.265
+ sb=0.265 sd=0.28 topography=normal area=0.063 perim=1.14
MMIN2 X Ab VGND VNB nfet_01v8 m=6 w=0.65 l=0.15 mult=1 sa=0.265
+ sb=0.265 sd=0.28 topography=normal area=0.063 perim=1.14
MMIP1 Ab A VPWR VPB pfet_01v8_hvt m=2 w=1.0 l=0.15 mult=1 sa=0.265
+ sb=0.265 sd=0.28 topography=normal area=0.063 perim=1.14
MMIP2 X Ab VPWR VPB pfet_01v8_hvt m=6 w=1.0 l=0.15 mult=1 sa=0.265
+ sb=0.265 sd=0.28 topography=normal area=0.063 perim=1.14
.ENDS sky130_fd_sc_hd__buf_6

.SUBCKT sky130_fd_sc_hd__bufinv_16 A VGND VNB VPB VPWR Y
*.PININFO A:I VGND:I VNB:I VPB:I VPWR:I Y:O
MMIN1 Ab A VGND VNB nfet_01v8 m=3 w=0.65 l=0.15 mult=1 sa=0.265
+ sb=0.265 sd=0.28 topography=normal area=0.063 perim=1.14
MMIN2 Abb Ab VGND VNB nfet_01v8 m=6 w=0.65 l=0.15 mult=1 sa=0.265
+ sb=0.265 sd=0.28 topography=normal area=0.063 perim=1.14
MMIN3 Y Abb VGND VNB nfet_01v8 m=16 w=0.65 l=0.15 mult=1 sa=0.265
+ sb=0.265 sd=0.28 topography=normal area=0.063 perim=1.14
MMIP1 Ab A VPWR VPB pfet_01v8_hvt m=3 w=1.0 l=0.15 mult=1 sa=0.265
+ sb=0.265 sd=0.28 topography=normal area=0.063 perim=1.14
MMIP2 Abb Ab VPWR VPB pfet_01v8_hvt m=6 w=1.0 l=0.15 mult=1 sa=0.265
+ sb=0.265 sd=0.28 topography=normal area=0.063 perim=1.14
MMIP3 Y Abb VPWR VPB pfet_01v8_hvt m=16 w=1.0 l=0.15 mult=1 sa=0.265
+ sb=0.265 sd=0.28 topography=normal area=0.063 perim=1.14
.ENDS sky130_fd_sc_hd__bufinv_16

.SUBCKT sky130_fd_sc_hd__clkbuf_1 A VGND VNB VPB VPWR X
*.PININFO A:I VGND:I VNB:I VPB:I VPWR:I X:O
MMIN0 Ab A VGND VNB nfet_01v8 m=1 w=0.52 l=0.15 mult=1 sa=0.265
+ sb=0.265 sd=0.28 topography=normal area=0.063 perim=1.14
MMIN1 X Ab VGND VNB nfet_01v8 m=1 w=0.52 l=0.15 mult=1 sa=0.265
+ sb=0.265 sd=0.28 topography=normal area=0.063 perim=1.14
MMIP0 Ab A VPWR VPB pfet_01v8_hvt m=1 w=0.79 l=0.15 mult=1 sa=0.265
+ sb=0.265 sd=0.28 topography=normal area=0.063 perim=1.14
MMIP1 X Ab VPWR VPB pfet_01v8_hvt m=1 w=0.79 l=0.15 mult=1 sa=0.265
+ sb=0.265 sd=0.28 topography=normal area=0.063 perim=1.14
.ENDS sky130_fd_sc_hd__clkbuf_1

.SUBCKT sky130_fd_sc_hd__clkbuf_16 A VGND VNB VPB VPWR X
*.PININFO A:I VGND:I VNB:I VPB:I VPWR:I X:O
MMIN0 Ab A VGND VNB nfet_01v8 m=4 w=0.42 l=0.15 mult=1 sa=0.265
+ sb=0.265 sd=0.28 topography=normal area=0.063 perim=1.14
MMIN1 X Ab VGND VNB nfet_01v8 m=16 w=0.42 l=0.15 mult=1 sa=0.265
+ sb=0.265 sd=0.28 topography=normal area=0.063 perim=1.14
MMIP0 Ab A VPWR VPB pfet_01v8_hvt m=4 w=1.0 l=0.15 mult=1 sa=0.265
+ sb=0.265 sd=0.28 topography=normal area=0.063 perim=1.14
MMIP1 X Ab VPWR VPB pfet_01v8_hvt m=16 w=1.0 l=0.15 mult=1 sa=0.265
+ sb=0.265 sd=0.28 topography=normal area=0.063 perim=1.14
.ENDS sky130_fd_sc_hd__clkbuf_16

.SUBCKT sky130_fd_sc_hd__clkbuf_2 A VGND VNB VPB VPWR X
*.PININFO A:I VGND:I VNB:I VPB:I VPWR:I X:O
MMIN0 Ab A VGND VNB nfet_01v8 m=1 w=0.42 l=0.15 mult=1 sa=0.265
+ sb=0.265 sd=0.28 topography=normal area=0.063 perim=1.14
MMIN1 X Ab VGND VNB nfet_01v8 m=2 w=0.42 l=0.15 mult=1 sa=0.265
+ sb=0.265 sd=0.28 topography=normal area=0.063 perim=1.14
MMIP0 Ab A VPWR VPB pfet_01v8_hvt m=1 w=1.0 l=0.15 mult=1 sa=0.265
+ sb=0.265 sd=0.28 topography=normal area=0.063 perim=1.14
MMIP1 X Ab VPWR VPB pfet_01v8_hvt m=2 w=1.0 l=0.15 mult=1 sa=0.265
+ sb=0.265 sd=0.28 topography=normal area=0.063 perim=1.14
.ENDS sky130_fd_sc_hd__clkbuf_2

.SUBCKT sky130_fd_sc_hd__clkbuf_8 A VGND VNB VPB VPWR X
*.PININFO A:I VGND:I VNB:I VPB:I VPWR:I X:O
MMIN0 Ab A VGND VNB nfet_01v8 m=2 w=0.42 l=0.15 mult=1 sa=0.265
+ sb=0.265 sd=0.28 topography=normal area=0.063 perim=1.14
MMIN1 X Ab VGND VNB nfet_01v8 m=8 w=0.42 l=0.15 mult=1 sa=0.265
+ sb=0.265 sd=0.28 topography=normal area=0.063 perim=1.14
MMIP0 Ab A VPWR VPB pfet_01v8_hvt m=2 w=1.0 l=0.15 mult=1 sa=0.265
+ sb=0.265 sd=0.28 topography=normal area=0.063 perim=1.14
MMIP1 X Ab VPWR VPB pfet_01v8_hvt m=8 w=1.0 l=0.15 mult=1 sa=0.265
+ sb=0.265 sd=0.28 topography=normal area=0.063 perim=1.14
.ENDS sky130_fd_sc_hd__clkbuf_8

.SUBCKT sky130_fd_sc_hd__clkinv_1 A VGND VNB VPB VPWR Y
*.PININFO A:I VGND:I VNB:I VPB:I VPWR:I Y:O
MMIN0 Y A VGND VNB nfet_01v8 m=1 w=0.42 l=0.15 mult=1 sa=0.265
+ sb=0.265 sd=0.28 topography=normal area=0.063 perim=1.14
MMIP0 Y A VPWR VPB pfet_01v8_hvt m=2 w=0.84 l=0.15 mult=1 sa=0.265
+ sb=0.265 sd=0.28 topography=normal area=0.063 perim=1.14
.ENDS sky130_fd_sc_hd__clkinv_1

.SUBCKT sky130_fd_sc_hd__clkinv_2 A VGND VNB VPB VPWR Y
*.PININFO A:I VGND:I VNB:I VPB:I VPWR:I Y:O
MMIN0 Y A VGND VNB nfet_01v8 m=2 w=0.42 l=0.15 mult=1 sa=0.265
+ sb=0.265 sd=0.28 topography=normal area=0.063 perim=1.14
MMIP0 Y A VPWR VPB pfet_01v8_hvt m=3 w=1.0 l=0.15 mult=1 sa=0.265
+ sb=0.265 sd=0.28 topography=normal area=0.063 perim=1.14
.ENDS sky130_fd_sc_hd__clkinv_2

.SUBCKT sky130_fd_sc_hd__clkinv_4 A VGND VNB VPB VPWR Y
*.PININFO A:I VGND:I VNB:I VPB:I VPWR:I Y:O
MMIN0 Y A VGND VNB nfet_01v8 m=4 w=0.42 l=0.15 mult=1 sa=0.265
+ sb=0.265 sd=0.28 topography=normal area=0.063 perim=1.14
MMIP0 Y A VPWR VPB pfet_01v8_hvt m=6 w=1.0 l=0.15 mult=1 sa=0.265
+ sb=0.265 sd=0.28 topography=normal area=0.063 perim=1.14
.ENDS sky130_fd_sc_hd__clkinv_4

.SUBCKT sky130_fd_sc_hd__clkinvlp_4 A VGND VNB VPB VPWR Y
*.PININFO A:I VGND:I VNB:I VPB:I VPWR:I Y:O
MMIP0 Y A VPWR VPB pfet_01v8_hvt m=4 w=1.0 l=0.25 mult=1 sa=0.265
+ sb=0.265 sd=0.28 topography=normal area=0.063 perim=1.14
MMIN0 Y A net31 VNB nfet_01v8 m=1 w=0.55 l=0.15 mult=1 sa=0.265
+ sb=0.265 sd=0.28 topography=normal area=0.063 perim=1.14
MI7 net35 A VGND VNB nfet_01v8 m=1 w=0.55 l=0.15 mult=1 sa=0.265
+ sb=0.265 sd=0.28 topography=normal area=0.063 perim=1.14
MI6 net31 A VGND VNB nfet_01v8 m=1 w=0.55 l=0.15 mult=1 sa=0.265
+ sb=0.265 sd=0.28 topography=normal area=0.063 perim=1.14
MI5 Y A net35 VNB nfet_01v8 m=1 w=0.55 l=0.15 mult=1 sa=0.265 sb=0.265
+ sd=0.28 topography=normal area=0.063 perim=1.14
.ENDS sky130_fd_sc_hd__clkinvlp_4

.SUBCKT sky130_fd_sc_hd__conb_1 VGND VNB VPB VPWR HI LO
*.PININFO VGND:I VNB:I VPB:I VPWR:I HI:O LO:O
rI12 VGND LO 0
rI11 HI VPWR 0
.ENDS sky130_fd_sc_hd__conb_1

.SUBCKT sky130_fd_sc_hd__dfxtp_1 CLK D VGND VNB VPB VPWR Q
*.PININFO CLK:I D:I VGND:I VNB:I VPB:I VPWR:I Q:O
MI657 M0 clkpos net79 VNB nfet_01v8 m=1 w=0.36 l=0.15 mult=1 sa=0.265
+ sb=0.265 sd=0.28 topography=normal area=0.063 perim=1.14
MI656 net79 M1 VGND VNB nfet_01v8 m=1 w=0.42 l=0.15 mult=1 sa=0.265
+ sb=0.265 sd=0.28 topography=normal area=0.063 perim=1.14
MI646 Q S1 VGND VNB nfet_01v8 m=1 w=0.65 l=0.15 mult=1 sa=0.265
+ sb=0.265 sd=0.28 topography=normal area=0.063 perim=1.14
MI648 db clkneg M0 VNB nfet_01v8 m=1 w=0.36 l=0.15 mult=1 sa=0.265
+ sb=0.265 sd=0.28 topography=normal area=0.063 perim=1.14
MI654 db D VGND VNB nfet_01v8 m=1 w=0.42 l=0.15 mult=1 sa=0.265
+ sb=0.265 sd=0.28 topography=normal area=0.063 perim=1.14
MI642 S0 clkneg net59 VNB nfet_01v8 m=1 w=0.36 l=0.15 mult=1 sa=0.265
+ sb=0.265 sd=0.28 topography=normal area=0.063 perim=1.14
MI641 net59 S1 VGND VNB nfet_01v8 m=1 w=0.42 l=0.15 mult=1 sa=0.265
+ sb=0.265 sd=0.28 topography=normal area=0.063 perim=1.14
MI652 M1 clkpos S0 VNB nfet_01v8 m=1 w=0.36 l=0.15 mult=1 sa=0.265
+ sb=0.265 sd=0.28 topography=normal area=0.063 perim=1.14
MI649 S1 S0 VGND VNB nfet_01v8 m=1 w=0.65 l=0.15 mult=1 sa=0.265
+ sb=0.265 sd=0.28 topography=normal area=0.063 perim=1.14
MI635 clkneg CLK VGND VNB nfet_01v8 m=1 w=0.42 l=0.15 mult=1 sa=0.265
+ sb=0.265 sd=0.28 topography=normal area=0.063 perim=1.14
MI636 clkpos clkneg VGND VNB nfet_01v8 m=1 w=0.42 l=0.15 mult=1
+ sa=0.265 sb=0.265 sd=0.28 topography=normal area=0.063 perim=1.14
MI634 M1 M0 VGND VNB nfet_01v8 m=1 w=0.64 l=0.15 mult=1 sa=0.265
+ sb=0.265 sd=0.28 topography=normal area=0.063 perim=1.14
MI659 M0 clkneg net107 VPB pfet_01v8_hvt m=1 w=0.42 l=0.15 mult=1
+ sa=0.265 sb=0.265 sd=0.28 topography=normal area=0.063 perim=1.14
MI650 S1 S0 VPWR VPB pfet_01v8_hvt m=1 w=1.0 l=0.15 mult=1 sa=0.265
+ sb=0.265 sd=0.28 topography=normal area=0.063 perim=1.14
MI644 S0 clkpos net122 VPB pfet_01v8_hvt m=1 w=0.42 l=0.15 mult=1
+ sa=0.265 sb=0.265 sd=0.28 topography=normal area=0.063 perim=1.14
MI639 M1 M0 VPWR VPB pfet_01v8_hvt m=1 w=0.75 l=0.15 mult=1 sa=0.265
+ sb=0.265 sd=0.28 topography=normal area=0.063 perim=1.14
MI643 net122 S1 VPWR VPB pfet_01v8_hvt m=1 w=0.42 l=0.15 mult=1
+ sa=0.265 sb=0.265 sd=0.28 topography=normal area=0.063 perim=1.14
MI638 clkneg CLK VPWR VPB pfet_01v8_hvt m=1 w=0.64 l=0.15 mult=1
+ sa=0.265 sb=0.265 sd=0.28 topography=normal area=0.063 perim=1.14
MI658 net107 M1 VPWR VPB pfet_01v8_hvt m=1 w=0.42 l=0.15 mult=1
+ sa=0.265 sb=0.265 sd=0.28 topography=normal area=0.063 perim=1.14
MI645 Q S1 VPWR VPB pfet_01v8_hvt m=1 w=1.0 l=0.15 mult=1 sa=0.265
+ sb=0.265 sd=0.28 topography=normal area=0.063 perim=1.14
MI651 db clkpos M0 VPB pfet_01v8_hvt m=1 w=0.42 l=0.15 mult=1 sa=0.265
+ sb=0.265 sd=0.28 topography=normal area=0.063 perim=1.14
MI655 db D VPWR VPB pfet_01v8_hvt m=1 w=0.42 l=0.15 mult=1 sa=0.265
+ sb=0.265 sd=0.28 topography=normal area=0.063 perim=1.14
MI653 M1 clkneg S0 VPB pfet_01v8_hvt m=1 w=0.42 l=0.15 mult=1 sa=0.265
+ sb=0.265 sd=0.28 topography=normal area=0.063 perim=1.14
MI637 clkpos clkneg VPWR VPB pfet_01v8_hvt m=1 w=0.64 l=0.15 mult=1
+ sa=0.265 sb=0.265 sd=0.28 topography=normal area=0.063 perim=1.14
.ENDS sky130_fd_sc_hd__dfxtp_1

.SUBCKT sky130_fd_sc_hd__fill_1 VGND VNB VPB VPWR
*.PININFO VGND:I VNB:I VPB:I VPWR:I
* Notes: Cell contains no devices
.ENDS sky130_fd_sc_hd__fill_1

.SUBCKT sky130_fd_sc_hd__fill_2 VGND VNB VPB VPWR
*.PININFO VGND:I VNB:I VPB:I VPWR:I
* Notes: Cell contains no devices
.ENDS sky130_fd_sc_hd__fill_2

.SUBCKT sky130_fd_sc_hd__fill_4 VGND VNB VPB VPWR
*.PININFO VGND:I VNB:I VPB:I VPWR:I
* Notes: Cell contains no devices
.ENDS sky130_fd_sc_hd__fill_4

.SUBCKT sky130_fd_sc_hd__fill_8 VGND VNB VPB VPWR
*.PININFO VGND:I VNB:I VPB:I VPWR:I
* Notes: Cell contains no devices
.ENDS sky130_fd_sc_hd__fill_8

.SUBCKT sky130_fd_sc_hd__inv_1 A VGND VNB VPB VPWR Y
*.PININFO A:I VGND:I VNB:I VPB:I VPWR:I Y:O
MMIN1 Y A VGND VNB nfet_01v8 m=1 w=0.65 l=0.15 mult=1 sa=0.265
+ sb=0.265 sd=0.28 topography=normal area=0.063 perim=1.14
MMIP1 Y A VPWR VPB pfet_01v8_hvt m=1 w=1.0 l=0.15 mult=1 sa=0.265
+ sb=0.265 sd=0.28 topography=normal area=0.063 perim=1.14
.ENDS sky130_fd_sc_hd__inv_1

.SUBCKT sky130_fd_sc_hd__inv_2 A VGND VNB VPB VPWR Y
*.PININFO A:I VGND:I VNB:I VPB:I VPWR:I Y:O
MMIN1 Y A VGND VNB nfet_01v8 m=2 w=0.65 l=0.15 mult=1 sa=0.265
+ sb=0.265 sd=0.28 topography=normal area=0.063 perim=1.14
MMIP1 Y A VPWR VPB pfet_01v8_hvt m=2 w=1.0 l=0.15 mult=1 sa=0.265
+ sb=0.265 sd=0.28 topography=normal area=0.063 perim=1.14
.ENDS sky130_fd_sc_hd__inv_2

.SUBCKT sky130_fd_sc_hd__inv_6 A VGND VNB VPB VPWR Y
*.PININFO A:I VGND:I VNB:I VPB:I VPWR:I Y:O
MMIN1 Y A VGND VNB nfet_01v8 m=6 w=0.65 l=0.15 mult=1 sa=0.265
+ sb=0.265 sd=0.28 topography=normal area=0.063 perim=1.14
MMIP1 Y A VPWR VPB pfet_01v8_hvt m=6 w=1.0 l=0.15 mult=1 sa=0.265
+ sb=0.265 sd=0.28 topography=normal area=0.063 perim=1.14
.ENDS sky130_fd_sc_hd__inv_6

.SUBCKT sky130_fd_sc_hd__nand2_1 A B VGND VNB VPB VPWR Y
*.PININFO A:I B:I VGND:I VNB:I VPB:I VPWR:I Y:O
MMP0 Y A VPWR VPB pfet_01v8_hvt m=1 w=1.0 l=0.15 mult=1 sa=0.265
+ sb=0.265 sd=0.28 topography=normal area=0.063 perim=1.14
MMP1 Y B VPWR VPB pfet_01v8_hvt m=1 w=1.0 l=0.15 mult=1 sa=0.265
+ sb=0.265 sd=0.28 topography=normal area=0.063 perim=1.14
MMN0 Y A sndA VNB nfet_01v8 m=1 w=0.65 l=0.15 mult=1 sa=0.265 sb=0.265
+ sd=0.28 topography=normal area=0.063 perim=1.14
MMN1 sndA B VGND VNB nfet_01v8 m=1 w=0.65 l=0.15 mult=1 sa=0.265
+ sb=0.265 sd=0.28 topography=normal area=0.063 perim=1.14
.ENDS sky130_fd_sc_hd__nand2_1

.SUBCKT sky130_fd_sc_hd__nand2_2 A B VGND VNB VPB VPWR Y
*.PININFO A:I B:I VGND:I VNB:I VPB:I VPWR:I Y:O
MMP0 Y A VPWR VPB pfet_01v8_hvt m=2 w=1.0 l=0.15 mult=1 sa=0.265
+ sb=0.265 sd=0.28 topography=normal area=0.063 perim=1.14
MMP1 Y B VPWR VPB pfet_01v8_hvt m=2 w=1.0 l=0.15 mult=1 sa=0.265
+ sb=0.265 sd=0.28 topography=normal area=0.063 perim=1.14
MMN0 Y A sndA VNB nfet_01v8 m=2 w=0.65 l=0.15 mult=1 sa=0.265 sb=0.265
+ sd=0.28 topography=normal area=0.063 perim=1.14
MMN1 sndA B VGND VNB nfet_01v8 m=2 w=0.65 l=0.15 mult=1 sa=0.265
+ sb=0.265 sd=0.28 topography=normal area=0.063 perim=1.14
.ENDS sky130_fd_sc_hd__nand2_2

.SUBCKT sky130_fd_sc_hd__nand2b_1 A_N B VGND VNB VPB VPWR Y
*.PININFO A_N:I B:I VGND:I VNB:I VPB:I VPWR:I Y:O
MMP0 Y A VPWR VPB pfet_01v8_hvt m=1 w=1.0 l=0.15 mult=1 sa=0.265
+ sb=0.265 sd=0.28 topography=normal area=0.063 perim=1.14
MMP1 Y B VPWR VPB pfet_01v8_hvt m=1 w=1.0 l=0.15 mult=1 sa=0.265
+ sb=0.265 sd=0.28 topography=normal area=0.063 perim=1.14
MMIP0 A A_N VPWR VPB pfet_01v8_hvt m=1 w=0.42 l=0.15 mult=1 sa=0.265
+ sb=0.265 sd=0.28 topography=normal area=0.063 perim=1.14
MMN0 Y A sndA VNB nfet_01v8 m=1 w=0.65 l=0.15 mult=1 sa=0.265 sb=0.265
+ sd=0.28 topography=normal area=0.063 perim=1.14
MMN1 sndA B VGND VNB nfet_01v8 m=1 w=0.65 l=0.15 mult=1 sa=0.265
+ sb=0.265 sd=0.28 topography=normal area=0.063 perim=1.14
MMIN0 A A_N VGND VNB nfet_01v8 m=1 w=0.42 l=0.15 mult=1 sa=0.265
+ sb=0.265 sd=0.28 topography=normal area=0.063 perim=1.14
.ENDS sky130_fd_sc_hd__nand2b_1

.SUBCKT sky130_fd_sc_hd__nand2b_4 A_N B VGND VNB VPB VPWR Y
*.PININFO A_N:I B:I VGND:I VNB:I VPB:I VPWR:I Y:O
MMP0 Y A VPWR VPB pfet_01v8_hvt m=4 w=1.0 l=0.15 mult=1 sa=0.265
+ sb=0.265 sd=0.28 topography=normal area=0.063 perim=1.14
MMP1 Y B VPWR VPB pfet_01v8_hvt m=4 w=1.0 l=0.15 mult=1 sa=0.265
+ sb=0.265 sd=0.28 topography=normal area=0.063 perim=1.14
MMIP0 A A_N VPWR VPB pfet_01v8_hvt m=1 w=1.0 l=0.15 mult=1 sa=0.265
+ sb=0.265 sd=0.28 topography=normal area=0.063 perim=1.14
MMN0 Y A sndA VNB nfet_01v8 m=4 w=0.65 l=0.15 mult=1 sa=0.265 sb=0.265
+ sd=0.28 topography=normal area=0.063 perim=1.14
MMN1 sndA B VGND VNB nfet_01v8 m=4 w=0.65 l=0.15 mult=1 sa=0.265
+ sb=0.265 sd=0.28 topography=normal area=0.063 perim=1.14
MMIN0 A A_N VGND VNB nfet_01v8 m=1 w=0.65 l=0.15 mult=1 sa=0.265
+ sb=0.265 sd=0.28 topography=normal area=0.063 perim=1.14
.ENDS sky130_fd_sc_hd__nand2b_4

.SUBCKT sky130_fd_sc_hd__nand3_1 A B C VGND VNB VPB VPWR Y
*.PININFO A:I B:I C:I VGND:I VNB:I VPB:I VPWR:I Y:O
MMP0 Y A VPWR VPB pfet_01v8_hvt m=1 w=1.0 l=0.15 mult=1 sa=0.265
+ sb=0.265 sd=0.28 topography=normal area=0.063 perim=1.14
MMP1 Y B VPWR VPB pfet_01v8_hvt m=1 w=1.0 l=0.15 mult=1 sa=0.265
+ sb=0.265 sd=0.28 topography=normal area=0.063 perim=1.14
MMP2 Y C VPWR VPB pfet_01v8_hvt m=1 w=1.0 l=0.15 mult=1 sa=0.265
+ sb=0.265 sd=0.28 topography=normal area=0.063 perim=1.14
MMN0 Y A sndA VNB nfet_01v8 m=1 w=0.65 l=0.15 mult=1 sa=0.265 sb=0.265
+ sd=0.28 topography=normal area=0.063 perim=1.14
MMN1 sndA B sndB VNB nfet_01v8 m=1 w=0.65 l=0.15 mult=1 sa=0.265
+ sb=0.265 sd=0.28 topography=normal area=0.063 perim=1.14
MMN2 sndB C VGND VNB nfet_01v8 m=1 w=0.65 l=0.15 mult=1 sa=0.265
+ sb=0.265 sd=0.28 topography=normal area=0.063 perim=1.14
.ENDS sky130_fd_sc_hd__nand3_1

.SUBCKT sky130_fd_sc_hd__nand3_2 A B C VGND VNB VPB VPWR Y
*.PININFO A:I B:I C:I VGND:I VNB:I VPB:I VPWR:I Y:O
MMP0 Y A VPWR VPB pfet_01v8_hvt m=2 w=1.0 l=0.15 mult=1 sa=0.265
+ sb=0.265 sd=0.28 topography=normal area=0.063 perim=1.14
MMP1 Y B VPWR VPB pfet_01v8_hvt m=2 w=1.0 l=0.15 mult=1 sa=0.265
+ sb=0.265 sd=0.28 topography=normal area=0.063 perim=1.14
MMP2 Y C VPWR VPB pfet_01v8_hvt m=2 w=1.0 l=0.15 mult=1 sa=0.265
+ sb=0.265 sd=0.28 topography=normal area=0.063 perim=1.14
MMN0 Y A sndA VNB nfet_01v8 m=2 w=0.65 l=0.15 mult=1 sa=0.265 sb=0.265
+ sd=0.28 topography=normal area=0.063 perim=1.14
MMN1 sndA B sndB VNB nfet_01v8 m=2 w=0.65 l=0.15 mult=1 sa=0.265
+ sb=0.265 sd=0.28 topography=normal area=0.063 perim=1.14
MMN2 sndB C VGND VNB nfet_01v8 m=2 w=0.65 l=0.15 mult=1 sa=0.265
+ sb=0.265 sd=0.28 topography=normal area=0.063 perim=1.14
.ENDS sky130_fd_sc_hd__nand3_2

.SUBCKT sky130_fd_sc_hd__nand3b_1 A_N B C VGND VNB VPB VPWR Y
*.PININFO A_N:I B:I C:I VGND:I VNB:I VPB:I VPWR:I Y:O
MMP0 Y A VPWR VPB pfet_01v8_hvt m=1 w=1.0 l=0.15 mult=1 sa=0.265
+ sb=0.265 sd=0.28 topography=normal area=0.063 perim=1.14
MMP1 Y B VPWR VPB pfet_01v8_hvt m=1 w=1.0 l=0.15 mult=1 sa=0.265
+ sb=0.265 sd=0.28 topography=normal area=0.063 perim=1.14
MMP2 Y C VPWR VPB pfet_01v8_hvt m=1 w=1.0 l=0.15 mult=1 sa=0.265
+ sb=0.265 sd=0.28 topography=normal area=0.063 perim=1.14
MMIP0 A A_N VPWR VPB pfet_01v8_hvt m=1 w=0.42 l=0.15 mult=1 sa=0.265
+ sb=0.265 sd=0.28 topography=normal area=0.063 perim=1.14
MMN0 Y A sndA VNB nfet_01v8 m=1 w=0.65 l=0.15 mult=1 sa=0.265 sb=0.265
+ sd=0.28 topography=normal area=0.063 perim=1.14
MMN1 sndA B sndB VNB nfet_01v8 m=1 w=0.65 l=0.15 mult=1 sa=0.265
+ sb=0.265 sd=0.28 topography=normal area=0.063 perim=1.14
MMN2 sndB C VGND VNB nfet_01v8 m=1 w=0.65 l=0.15 mult=1 sa=0.265
+ sb=0.265 sd=0.28 topography=normal area=0.063 perim=1.14
MMIN0 A A_N VGND VNB nfet_01v8 m=1 w=0.42 l=0.15 mult=1 sa=0.265
+ sb=0.265 sd=0.28 topography=normal area=0.063 perim=1.14
.ENDS sky130_fd_sc_hd__nand3b_1

.SUBCKT sky130_fd_sc_hd__nor2_1 A B VGND VNB VPB VPWR Y
*.PININFO A:I B:I VGND:I VNB:I VPB:I VPWR:I Y:O
MMP0 VPWR A sndPA VPB pfet_01v8_hvt m=1 w=1.0 l=0.15 mult=1 sa=0.265
+ sb=0.265 sd=0.28 topography=normal area=0.063 perim=1.14
MMP1 sndPA B Y VPB pfet_01v8_hvt m=1 w=1.0 l=0.15 mult=1 sa=0.265
+ sb=0.265 sd=0.28 topography=normal area=0.063 perim=1.14
MMN0 Y A VGND VNB nfet_01v8 m=1 w=0.65 l=0.15 mult=1 sa=0.265 sb=0.265
+ sd=0.28 topography=normal area=0.063 perim=1.14
MMN1 Y B VGND VNB nfet_01v8 m=1 w=0.65 l=0.15 mult=1 sa=0.265 sb=0.265
+ sd=0.28 topography=normal area=0.063 perim=1.14
.ENDS sky130_fd_sc_hd__nor2_1

.SUBCKT sky130_fd_sc_hd__nor2b_1 A B_N VGND VNB VPB VPWR Y
*.PININFO A:I B_N:I VGND:I VNB:I VPB:I VPWR:I Y:O
MMP0 VPWR A sndPA VPB pfet_01v8_hvt m=1 w=1.0 l=0.15 mult=1 sa=0.265
+ sb=0.265 sd=0.28 topography=normal area=0.063 perim=1.14
MMP1 sndPA B Y VPB pfet_01v8_hvt m=1 w=1.0 l=0.15 mult=1 sa=0.265
+ sb=0.265 sd=0.28 topography=normal area=0.063 perim=1.14
MMIP1 B B_N VPWR VPB pfet_01v8_hvt m=1 w=0.42 l=0.15 mult=1 sa=0.265
+ sb=0.265 sd=0.28 topography=normal area=0.063 perim=1.14
MMN0 Y A VGND VNB nfet_01v8 m=1 w=0.65 l=0.15 mult=1 sa=0.265 sb=0.265
+ sd=0.28 topography=normal area=0.063 perim=1.14
MMN1 Y B VGND VNB nfet_01v8 m=1 w=0.65 l=0.15 mult=1 sa=0.265 sb=0.265
+ sd=0.28 topography=normal area=0.063 perim=1.14
MMIN1 B B_N VGND VNB nfet_01v8 m=1 w=0.42 l=0.15 mult=1 sa=0.265
+ sb=0.265 sd=0.28 topography=normal area=0.063 perim=1.14
.ENDS sky130_fd_sc_hd__nor2b_1

.SUBCKT sky130_fd_sc_hd__nor3_1 A B C VGND VNB VPB VPWR Y
*.PININFO A:I B:I C:I VGND:I VNB:I VPB:I VPWR:I Y:O
MMP0 VPWR A sndPA VPB pfet_01v8_hvt m=1 w=1.0 l=0.15 mult=1 sa=0.265
+ sb=0.265 sd=0.28 topography=normal area=0.063 perim=1.14
MMP1 sndPA B sndPB VPB pfet_01v8_hvt m=1 w=1.0 l=0.15 mult=1 sa=0.265
+ sb=0.265 sd=0.28 topography=normal area=0.063 perim=1.14
MMP2 sndPB C Y VPB pfet_01v8_hvt m=1 w=1.0 l=0.15 mult=1 sa=0.265
+ sb=0.265 sd=0.28 topography=normal area=0.063 perim=1.14
MMN0 Y A VGND VNB nfet_01v8 m=1 w=0.65 l=0.15 mult=1 sa=0.265 sb=0.265
+ sd=0.28 topography=normal area=0.063 perim=1.14
MMN1 Y B VGND VNB nfet_01v8 m=1 w=0.65 l=0.15 mult=1 sa=0.265 sb=0.265
+ sd=0.28 topography=normal area=0.063 perim=1.14
MMN2 Y C VGND VNB nfet_01v8 m=1 w=0.65 l=0.15 mult=1 sa=0.265 sb=0.265
+ sd=0.28 topography=normal area=0.063 perim=1.14
.ENDS sky130_fd_sc_hd__nor3_1

.SUBCKT sky130_fd_sc_hd__o211a_1 A1 A2 B1 C1 VGND VNB VPB VPWR X
*.PININFO A1:I A2:I B1:I C1:I VGND:I VNB:I VPB:I VPWR:I X:O
MMPA0 VPWR A1 sndA1 VPB pfet_01v8_hvt m=1 w=1.0 l=0.15 mult=1 sa=0.265
+ sb=0.265 sd=0.28 topography=normal area=0.063 perim=1.14
MMPA1 sndA1 A2 y VPB pfet_01v8_hvt m=1 w=1.0 l=0.15 mult=1 sa=0.265
+ sb=0.265 sd=0.28 topography=normal area=0.063 perim=1.14
MMPB0 VPWR B1 y VPB pfet_01v8_hvt m=1 w=1.0 l=0.15 mult=1 sa=0.265
+ sb=0.265 sd=0.28 topography=normal area=0.063 perim=1.14
MMPC0 VPWR C1 y VPB pfet_01v8_hvt m=1 w=1.0 l=0.15 mult=1 sa=0.265
+ sb=0.265 sd=0.28 topography=normal area=0.063 perim=1.14
MMIPX X y VPWR VPB pfet_01v8_hvt m=1 w=1.0 l=0.15 mult=1 sa=0.265
+ sb=0.265 sd=0.28 topography=normal area=0.063 perim=1.14
MMNA0 pndA A1 VGND VNB nfet_01v8 m=1 w=0.65 l=0.15 mult=1 sa=0.265
+ sb=0.265 sd=0.28 topography=normal area=0.063 perim=1.14
MMNA1 pndA A2 VGND VNB nfet_01v8 m=1 w=0.65 l=0.15 mult=1 sa=0.265
+ sb=0.265 sd=0.28 topography=normal area=0.063 perim=1.14
MMNB0 pndB B1 pndA VNB nfet_01v8 m=1 w=0.65 l=0.15 mult=1 sa=0.265
+ sb=0.265 sd=0.28 topography=normal area=0.063 perim=1.14
MMNC0 y C1 pndB VNB nfet_01v8 m=1 w=0.65 l=0.15 mult=1 sa=0.265
+ sb=0.265 sd=0.28 topography=normal area=0.063 perim=1.14
MMINX X y VGND VNB nfet_01v8 m=1 w=0.65 l=0.15 mult=1 sa=0.265
+ sb=0.265 sd=0.28 topography=normal area=0.063 perim=1.14
.ENDS sky130_fd_sc_hd__o211a_1

.SUBCKT sky130_fd_sc_hd__o211a_2 A1 A2 B1 C1 VGND VNB VPB VPWR X
*.PININFO A1:I A2:I B1:I C1:I VGND:I VNB:I VPB:I VPWR:I X:O
MMPA0 VPWR A1 sndA1 VPB pfet_01v8_hvt m=1 w=1.0 l=0.15 mult=1 sa=0.265
+ sb=0.265 sd=0.28 topography=normal area=0.063 perim=1.14
MMPA1 sndA1 A2 y VPB pfet_01v8_hvt m=1 w=1.0 l=0.15 mult=1 sa=0.265
+ sb=0.265 sd=0.28 topography=normal area=0.063 perim=1.14
MMPB0 VPWR B1 y VPB pfet_01v8_hvt m=1 w=1.0 l=0.15 mult=1 sa=0.265
+ sb=0.265 sd=0.28 topography=normal area=0.063 perim=1.14
MMPC0 VPWR C1 y VPB pfet_01v8_hvt m=1 w=1.0 l=0.15 mult=1 sa=0.265
+ sb=0.265 sd=0.28 topography=normal area=0.063 perim=1.14
MMIPX X y VPWR VPB pfet_01v8_hvt m=2 w=1.0 l=0.15 mult=1 sa=0.265
+ sb=0.265 sd=0.28 topography=normal area=0.063 perim=1.14
MMNA0 pndA A1 VGND VNB nfet_01v8 m=1 w=0.65 l=0.15 mult=1 sa=0.265
+ sb=0.265 sd=0.28 topography=normal area=0.063 perim=1.14
MMNA1 pndA A2 VGND VNB nfet_01v8 m=1 w=0.65 l=0.15 mult=1 sa=0.265
+ sb=0.265 sd=0.28 topography=normal area=0.063 perim=1.14
MMNB0 pndB B1 pndA VNB nfet_01v8 m=1 w=0.65 l=0.15 mult=1 sa=0.265
+ sb=0.265 sd=0.28 topography=normal area=0.063 perim=1.14
MMNC0 y C1 pndB VNB nfet_01v8 m=1 w=0.65 l=0.15 mult=1 sa=0.265
+ sb=0.265 sd=0.28 topography=normal area=0.063 perim=1.14
MMINX X y VGND VNB nfet_01v8 m=2 w=0.65 l=0.15 mult=1 sa=0.265
+ sb=0.265 sd=0.28 topography=normal area=0.063 perim=1.14
.ENDS sky130_fd_sc_hd__o211a_2

.SUBCKT sky130_fd_sc_hd__o211ai_1 A1 A2 B1 C1 VGND VNB VPB VPWR Y
*.PININFO A1:I A2:I B1:I C1:I VGND:I VNB:I VPB:I VPWR:I Y:O
MMPA0 VPWR A1 sndA1 VPB pfet_01v8_hvt m=1 w=1.0 l=0.15 mult=1 sa=0.265
+ sb=0.265 sd=0.28 topography=normal area=0.063 perim=1.14
MMPA1 sndA1 A2 Y VPB pfet_01v8_hvt m=1 w=1.0 l=0.15 mult=1 sa=0.265
+ sb=0.265 sd=0.28 topography=normal area=0.063 perim=1.14
MMPB0 VPWR B1 Y VPB pfet_01v8_hvt m=1 w=1.0 l=0.15 mult=1 sa=0.265
+ sb=0.265 sd=0.28 topography=normal area=0.063 perim=1.14
MMPC0 VPWR C1 Y VPB pfet_01v8_hvt m=1 w=1.0 l=0.15 mult=1 sa=0.265
+ sb=0.265 sd=0.28 topography=normal area=0.063 perim=1.14
MMNA0 pndA A1 VGND VNB nfet_01v8 m=1 w=0.65 l=0.15 mult=1 sa=0.265
+ sb=0.265 sd=0.28 topography=normal area=0.063 perim=1.14
MMNA1 pndA A2 VGND VNB nfet_01v8 m=1 w=0.65 l=0.15 mult=1 sa=0.265
+ sb=0.265 sd=0.28 topography=normal area=0.063 perim=1.14
MMNB0 pndB B1 pndA VNB nfet_01v8 m=1 w=0.65 l=0.15 mult=1 sa=0.265
+ sb=0.265 sd=0.28 topography=normal area=0.063 perim=1.14
MMNC0 Y C1 pndB VNB nfet_01v8 m=1 w=0.65 l=0.15 mult=1 sa=0.265
+ sb=0.265 sd=0.28 topography=normal area=0.063 perim=1.14
.ENDS sky130_fd_sc_hd__o211ai_1

.SUBCKT sky130_fd_sc_hd__o21a_1 A1 A2 B1 VGND VNB VPB VPWR X
*.PININFO A1:I A2:I B1:I VGND:I VNB:I VPB:I VPWR:I X:O
MMPA0 VPWR A1 sndA1 VPB pfet_01v8_hvt m=1 w=1.0 l=0.15 mult=1 sa=0.265
+ sb=0.265 sd=0.28 topography=normal area=0.063 perim=1.14
MMPA1 sndA1 A2 y VPB pfet_01v8_hvt m=1 w=1.0 l=0.15 mult=1 sa=0.265
+ sb=0.265 sd=0.28 topography=normal area=0.063 perim=1.14
MMPB0 VPWR B1 y VPB pfet_01v8_hvt m=1 w=1.0 l=0.15 mult=1 sa=0.265
+ sb=0.265 sd=0.28 topography=normal area=0.063 perim=1.14
MMIPX X y VPWR VPB pfet_01v8_hvt m=1 w=1.0 l=0.15 mult=1 sa=0.265
+ sb=0.265 sd=0.28 topography=normal area=0.063 perim=1.14
MMNA0 pndA A1 VGND VNB nfet_01v8 m=1 w=0.65 l=0.15 mult=1 sa=0.265
+ sb=0.265 sd=0.28 topography=normal area=0.063 perim=1.14
MMNA1 pndA A2 VGND VNB nfet_01v8 m=1 w=0.65 l=0.15 mult=1 sa=0.265
+ sb=0.265 sd=0.28 topography=normal area=0.063 perim=1.14
MMNB0 y B1 pndA VNB nfet_01v8 m=1 w=0.65 l=0.15 mult=1 sa=0.265
+ sb=0.265 sd=0.28 topography=normal area=0.063 perim=1.14
MMINX X y VGND VNB nfet_01v8 m=1 w=0.65 l=0.15 mult=1 sa=0.265
+ sb=0.265 sd=0.28 topography=normal area=0.063 perim=1.14
.ENDS sky130_fd_sc_hd__o21a_1

.SUBCKT sky130_fd_sc_hd__o21ai_0 A1 A2 B1 VGND VNB VPB VPWR Y
*.PININFO A1:I A2:I B1:I VGND:I VNB:I VPB:I VPWR:I Y:O
MMPA0 VPWR A1 sndA1 VPB pfet_01v8_hvt m=1 w=0.64 l=0.15 mult=1
+ sa=0.265 sb=0.265 sd=0.28 topography=normal area=0.063 perim=1.14
MMPA1 sndA1 A2 Y VPB pfet_01v8_hvt m=1 w=0.64 l=0.15 mult=1 sa=0.265
+ sb=0.265 sd=0.28 topography=normal area=0.063 perim=1.14
MMPB0 VPWR B1 Y VPB pfet_01v8_hvt m=1 w=0.64 l=0.15 mult=1 sa=0.265
+ sb=0.265 sd=0.28 topography=normal area=0.063 perim=1.14
MMNA0 pndA A1 VGND VNB nfet_01v8 m=1 w=0.42 l=0.15 mult=1 sa=0.265
+ sb=0.265 sd=0.28 topography=normal area=0.063 perim=1.14
MMNA1 pndA A2 VGND VNB nfet_01v8 m=1 w=0.42 l=0.15 mult=1 sa=0.265
+ sb=0.265 sd=0.28 topography=normal area=0.063 perim=1.14
MMNB0 Y B1 pndA VNB nfet_01v8 m=1 w=0.42 l=0.15 mult=1 sa=0.265
+ sb=0.265 sd=0.28 topography=normal area=0.063 perim=1.14
.ENDS sky130_fd_sc_hd__o21ai_0

.SUBCKT sky130_fd_sc_hd__o21ai_1 A1 A2 B1 VGND VNB VPB VPWR Y
*.PININFO A1:I A2:I B1:I VGND:I VNB:I VPB:I VPWR:I Y:O
MMPA0 VPWR A1 sndA1 VPB pfet_01v8_hvt m=1 w=1.0 l=0.15 mult=1 sa=0.265
+ sb=0.265 sd=0.28 topography=normal area=0.063 perim=1.14
MMPA1 sndA1 A2 Y VPB pfet_01v8_hvt m=1 w=1.0 l=0.15 mult=1 sa=0.265
+ sb=0.265 sd=0.28 topography=normal area=0.063 perim=1.14
MMPB0 VPWR B1 Y VPB pfet_01v8_hvt m=1 w=0.7 l=0.15 mult=1 sa=0.265
+ sb=0.265 sd=0.28 topography=normal area=0.063 perim=1.14
MMNA0 pndA A1 VGND VNB nfet_01v8 m=1 w=0.65 l=0.15 mult=1 sa=0.265
+ sb=0.265 sd=0.28 topography=normal area=0.063 perim=1.14
MMNA1 pndA A2 VGND VNB nfet_01v8 m=1 w=0.65 l=0.15 mult=1 sa=0.265
+ sb=0.265 sd=0.28 topography=normal area=0.063 perim=1.14
MMNB0 Y B1 pndA VNB nfet_01v8 m=1 w=0.65 l=0.15 mult=1 sa=0.265
+ sb=0.265 sd=0.28 topography=normal area=0.063 perim=1.14
.ENDS sky130_fd_sc_hd__o21ai_1

.SUBCKT sky130_fd_sc_hd__o21bai_1 A1 A2 B1_N VGND VNB VPB VPWR Y
*.PININFO A1:I A2:I B1_N:I VGND:I VNB:I VPB:I VPWR:I Y:O
MMPA0 VPWR A1 sndA1 VPB pfet_01v8_hvt m=1 w=1.0 l=0.15 mult=1 sa=0.265
+ sb=0.265 sd=0.28 topography=normal area=0.063 perim=1.14
MMPA1 sndA1 A2 Y VPB pfet_01v8_hvt m=1 w=1.0 l=0.15 mult=1 sa=0.265
+ sb=0.265 sd=0.28 topography=normal area=0.063 perim=1.14
MMPB0 VPWR B1 Y VPB pfet_01v8_hvt m=1 w=1.0 l=0.15 mult=1 sa=0.265
+ sb=0.265 sd=0.28 topography=normal area=0.063 perim=1.14
MMIPB1N B1 B1_N VPWR VPB pfet_01v8_hvt m=1 w=0.42 l=0.15 mult=1
+ sa=0.265 sb=0.265 sd=0.28 topography=normal area=0.063 perim=1.14
MMNA0 pndA A1 VGND VNB nfet_01v8 m=1 w=0.65 l=0.15 mult=1 sa=0.265
+ sb=0.265 sd=0.28 topography=normal area=0.063 perim=1.14
MMNA1 pndA A2 VGND VNB nfet_01v8 m=1 w=0.65 l=0.15 mult=1 sa=0.265
+ sb=0.265 sd=0.28 topography=normal area=0.063 perim=1.14
MMNB0 Y B1 pndA VNB nfet_01v8 m=1 w=0.65 l=0.15 mult=1 sa=0.265
+ sb=0.265 sd=0.28 topography=normal area=0.063 perim=1.14
MMINB1N B1 B1_N VGND VNB nfet_01v8 m=1 w=0.42 l=0.15 mult=1 sa=0.265
+ sb=0.265 sd=0.28 topography=normal area=0.063 perim=1.14
.ENDS sky130_fd_sc_hd__o21bai_1

.SUBCKT sky130_fd_sc_hd__or2_1 A B VGND VNB VPB VPWR X
*.PININFO A:I B:I VGND:I VNB:I VPB:I VPWR:I X:O
MMP0 VPWR A sndPA VPB pfet_01v8_hvt m=1 w=0.42 l=0.15 mult=1 sa=0.265
+ sb=0.265 sd=0.28 topography=normal area=0.063 perim=1.14
MMP1 sndPA B y VPB pfet_01v8_hvt m=1 w=0.42 l=0.15 mult=1 sa=0.265
+ sb=0.265 sd=0.28 topography=normal area=0.063 perim=1.14
MMIP2 X y VPWR VPB pfet_01v8_hvt m=1 w=1.0 l=0.15 mult=1 sa=0.265
+ sb=0.265 sd=0.28 topography=normal area=0.063 perim=1.14
MMN0 y A VGND VNB nfet_01v8 m=1 w=0.42 l=0.15 mult=1 sa=0.265 sb=0.265
+ sd=0.28 topography=normal area=0.063 perim=1.14
MMN1 y B VGND VNB nfet_01v8 m=1 w=0.42 l=0.15 mult=1 sa=0.265 sb=0.265
+ sd=0.28 topography=normal area=0.063 perim=1.14
MMIN2 X y VGND VNB nfet_01v8 m=1 w=0.65 l=0.15 mult=1 sa=0.265
+ sb=0.265 sd=0.28 topography=normal area=0.063 perim=1.14
.ENDS sky130_fd_sc_hd__or2_1

.SUBCKT sky130_fd_sc_hd__or2_2 A B VGND VNB VPB VPWR X
*.PININFO A:I B:I VGND:I VNB:I VPB:I VPWR:I X:O
MMP0 VPWR A sndPA VPB pfet_01v8_hvt m=1 w=0.42 l=0.15 mult=1 sa=0.265
+ sb=0.265 sd=0.28 topography=normal area=0.063 perim=1.14
MMP1 sndPA B y VPB pfet_01v8_hvt m=1 w=0.42 l=0.15 mult=1 sa=0.265
+ sb=0.265 sd=0.28 topography=normal area=0.063 perim=1.14
MMIP2 X y VPWR VPB pfet_01v8_hvt m=2 w=1.0 l=0.15 mult=1 sa=0.265
+ sb=0.265 sd=0.28 topography=normal area=0.063 perim=1.14
MMN0 y A VGND VNB nfet_01v8 m=1 w=0.42 l=0.15 mult=1 sa=0.265 sb=0.265
+ sd=0.28 topography=normal area=0.063 perim=1.14
MMN1 y B VGND VNB nfet_01v8 m=1 w=0.42 l=0.15 mult=1 sa=0.265 sb=0.265
+ sd=0.28 topography=normal area=0.063 perim=1.14
MMIN2 X y VGND VNB nfet_01v8 m=2 w=0.65 l=0.15 mult=1 sa=0.265
+ sb=0.265 sd=0.28 topography=normal area=0.063 perim=1.14
.ENDS sky130_fd_sc_hd__or2_2

.SUBCKT sky130_fd_sc_hd__tapvpwrvgnd_1 VGND VPWR
*.PININFO VGND:I VPWR:I
* Notes: substrate is tied to vgnd and well is tied to vpwr in the
*        cell and do not appear as pins.
.ENDS sky130_fd_sc_hd__tapvpwrvgnd_1

.SUBCKT sky130_fd_sc_hd__xnor2_1 A B VGND VNB VPB VPWR Y
*.PININFO A:I B:I VGND:I VNB:I VPB:I VPWR:I Y:O
MMNnand0 VGND A sndNA VNB nfet_01v8 m=1 w=0.65 l=0.15 mult=1 sa=0.265
+ sb=0.265 sd=0.28 topography=normal area=0.063 perim=1.14
MMNnand1 sndNA B inand VNB nfet_01v8 m=1 w=0.65 l=0.15 mult=1 sa=0.265
+ sb=0.265 sd=0.28 topography=normal area=0.063 perim=1.14
MMNaoi10 nmid A VGND VNB nfet_01v8 m=1 w=0.65 l=0.15 mult=1 sa=0.265
+ sb=0.265 sd=0.28 topography=normal area=0.063 perim=1.14
MMNaoi11 nmid B VGND VNB nfet_01v8 m=1 w=0.65 l=0.15 mult=1 sa=0.265
+ sb=0.265 sd=0.28 topography=normal area=0.063 perim=1.14
MMNaoi20 Y inand nmid VNB nfet_01v8 m=1 w=0.65 l=0.15 mult=1 sa=0.265
+ sb=0.265 sd=0.28 topography=normal area=0.063 perim=1.14
MMPnand0 inand A VPWR VPB pfet_01v8_hvt m=1 w=1.0 l=0.15 mult=1
+ sa=0.265 sb=0.265 sd=0.28 topography=normal area=0.063 perim=1.14
MMPnand1 inand B VPWR VPB pfet_01v8_hvt m=1 w=1.0 l=0.15 mult=1
+ sa=0.265 sb=0.265 sd=0.28 topography=normal area=0.063 perim=1.14
MMPaoi10 VPWR A sndPA VPB pfet_01v8_hvt m=1 w=1.0 l=0.15 mult=1
+ sa=0.265 sb=0.265 sd=0.28 topography=normal area=0.063 perim=1.14
MMPaoi11 sndPA B Y VPB pfet_01v8_hvt m=1 w=1.0 l=0.15 mult=1 sa=0.265
+ sb=0.265 sd=0.28 topography=normal area=0.063 perim=1.14
MMPaoi20 Y inand VPWR VPB pfet_01v8_hvt m=1 w=1.0 l=0.15 mult=1
+ sa=0.265 sb=0.265 sd=0.28 topography=normal area=0.063 perim=1.14
.ENDS sky130_fd_sc_hd__xnor2_1

.SUBCKT sky130_fd_sc_hd__xnor2_2 A B VGND VNB VPB VPWR Y
*.PININFO A:I B:I VGND:I VNB:I VPB:I VPWR:I Y:O
MMNnand0 VGND A sndNA VNB nfet_01v8 m=2 w=0.65 l=0.15 mult=1 sa=0.265
+ sb=0.265 sd=0.28 topography=normal area=0.063 perim=1.14
MMNnand1 sndNA B inand VNB nfet_01v8 m=2 w=0.65 l=0.15 mult=1 sa=0.265
+ sb=0.265 sd=0.28 topography=normal area=0.063 perim=1.14
MMNaoi10 nmid A VGND VNB nfet_01v8 m=2 w=0.65 l=0.15 mult=1 sa=0.265
+ sb=0.265 sd=0.28 topography=normal area=0.063 perim=1.14
MMNaoi11 nmid B VGND VNB nfet_01v8 m=2 w=0.65 l=0.15 mult=1 sa=0.265
+ sb=0.265 sd=0.28 topography=normal area=0.063 perim=1.14
MMNaoi20 Y inand nmid VNB nfet_01v8 m=2 w=0.65 l=0.15 mult=1 sa=0.265
+ sb=0.265 sd=0.28 topography=normal area=0.063 perim=1.14
MMPnand0 inand A VPWR VPB pfet_01v8_hvt m=2 w=1.0 l=0.15 mult=1
+ sa=0.265 sb=0.265 sd=0.28 topography=normal area=0.063 perim=1.14
MMPnand1 inand B VPWR VPB pfet_01v8_hvt m=2 w=1.0 l=0.15 mult=1
+ sa=0.265 sb=0.265 sd=0.28 topography=normal area=0.063 perim=1.14
MMPaoi10 VPWR A sndPA VPB pfet_01v8_hvt m=2 w=1.0 l=0.15 mult=1
+ sa=0.265 sb=0.265 sd=0.28 topography=normal area=0.063 perim=1.14
MMPaoi11 sndPA B Y VPB pfet_01v8_hvt m=2 w=1.0 l=0.15 mult=1 sa=0.265
+ sb=0.265 sd=0.28 topography=normal area=0.063 perim=1.14
MMPaoi20 Y inand VPWR VPB pfet_01v8_hvt m=2 w=1.0 l=0.15 mult=1
+ sa=0.265 sb=0.265 sd=0.28 topography=normal area=0.063 perim=1.14
.ENDS sky130_fd_sc_hd__xnor2_2

.SUBCKT sky130_fd_sc_hd__xor2_1 A B VGND VNB VPB VPWR X
*.PININFO A:I B:I VGND:I VNB:I VPB:I VPWR:I X:O
MMNnor0 inor A VGND VNB nfet_01v8 m=1 w=0.65 l=0.15 mult=1 sa=0.265
+ sb=0.265 sd=0.28 topography=normal area=0.063 perim=1.14
MMNnor1 inor B VGND VNB nfet_01v8 m=1 w=0.65 l=0.15 mult=1 sa=0.265
+ sb=0.265 sd=0.28 topography=normal area=0.063 perim=1.14
MMNaoi10 VGND A sndNA VNB nfet_01v8 m=1 w=0.65 l=0.15 mult=1 sa=0.265
+ sb=0.265 sd=0.28 topography=normal area=0.063 perim=1.14
MMNaoi11 sndNA B X VNB nfet_01v8 m=1 w=0.65 l=0.15 mult=1 sa=0.265
+ sb=0.265 sd=0.28 topography=normal area=0.063 perim=1.14
MMNaoi20 X inor VGND VNB nfet_01v8 m=1 w=0.65 l=0.15 mult=1 sa=0.265
+ sb=0.265 sd=0.28 topography=normal area=0.063 perim=1.14
MMPnor0 VPWR A sndPA VPB pfet_01v8_hvt m=1 w=1.0 l=0.15 mult=1
+ sa=0.265 sb=0.265 sd=0.28 topography=normal area=0.063 perim=1.14
MMPnor1 sndPA B inor VPB pfet_01v8_hvt m=1 w=1.0 l=0.15 mult=1
+ sa=0.265 sb=0.265 sd=0.28 topography=normal area=0.063 perim=1.14
MMPaoi10 pmid A VPWR VPB pfet_01v8_hvt m=1 w=1.0 l=0.15 mult=1
+ sa=0.265 sb=0.265 sd=0.28 topography=normal area=0.063 perim=1.14
MMPaoi11 pmid B VPWR VPB pfet_01v8_hvt m=1 w=1.0 l=0.15 mult=1
+ sa=0.265 sb=0.265 sd=0.28 topography=normal area=0.063 perim=1.14
MMPaoi20 X inor pmid VPB pfet_01v8_hvt m=1 w=1.0 l=0.15 mult=1
+ sa=0.265 sb=0.265 sd=0.28 topography=normal area=0.063 perim=1.14
.ENDS sky130_fd_sc_hd__xor2_1

.SUBCKT sky130_fd_sc_hd__xor2_4 A B VGND VNB VPB VPWR X
*.PININFO A:I B:I VGND:I VNB:I VPB:I VPWR:I X:O
MMNnor0 inor A VGND VNB nfet_01v8 m=4 w=0.65 l=0.15 mult=1 sa=0.265
+ sb=0.265 sd=0.28 topography=normal area=0.063 perim=1.14
MMNnor1 inor B VGND VNB nfet_01v8 m=4 w=0.65 l=0.15 mult=1 sa=0.265
+ sb=0.265 sd=0.28 topography=normal area=0.063 perim=1.14
MMNaoi10 VGND A sndNA VNB nfet_01v8 m=4 w=0.65 l=0.15 mult=1 sa=0.265
+ sb=0.265 sd=0.28 topography=normal area=0.063 perim=1.14
MMNaoi11 sndNA B X VNB nfet_01v8 m=4 w=0.65 l=0.15 mult=1 sa=0.265
+ sb=0.265 sd=0.28 topography=normal area=0.063 perim=1.14
MMNaoi20 X inor VGND VNB nfet_01v8 m=4 w=0.65 l=0.15 mult=1 sa=0.265
+ sb=0.265 sd=0.28 topography=normal area=0.063 perim=1.14
MMPnor0 VPWR A sndPA VPB pfet_01v8_hvt m=4 w=1.0 l=0.15 mult=1
+ sa=0.265 sb=0.265 sd=0.28 topography=normal area=0.063 perim=1.14
MMPnor1 sndPA B inor VPB pfet_01v8_hvt m=4 w=1.0 l=0.15 mult=1
+ sa=0.265 sb=0.265 sd=0.28 topography=normal area=0.063 perim=1.14
MMPaoi10 pmid A VPWR VPB pfet_01v8_hvt m=4 w=1.0 l=0.15 mult=1
+ sa=0.265 sb=0.265 sd=0.28 topography=normal area=0.063 perim=1.14
MMPaoi11 pmid B VPWR VPB pfet_01v8_hvt m=4 w=1.0 l=0.15 mult=1
+ sa=0.265 sb=0.265 sd=0.28 topography=normal area=0.063 perim=1.14
MMPaoi20 X inor pmid VPB pfet_01v8_hvt m=4 w=1.0 l=0.15 mult=1
+ sa=0.265 sb=0.265 sd=0.28 topography=normal area=0.063 perim=1.14
.ENDS sky130_fd_sc_hd__xor2_4

* CDL Netlist generated by OpenROAD

*.BUSDELIMITER [

.SUBCKT axis_eth_fcs_reset clk output_fcs[0] output_fcs[10]
+ output_fcs[11] output_fcs[12] output_fcs[13] output_fcs[14]
+ output_fcs[15] output_fcs[16] output_fcs[17] output_fcs[18]
+ output_fcs[19] output_fcs[1] output_fcs[20] output_fcs[21]
+ output_fcs[22] output_fcs[23] output_fcs[24] output_fcs[25]
+ output_fcs[26] output_fcs[27] output_fcs[28] output_fcs[29]
+ output_fcs[2] output_fcs[30] output_fcs[31] output_fcs[3]
+ output_fcs[4] output_fcs[5] output_fcs[6] output_fcs[7] output_fcs[8]
+ output_fcs[9] output_fcs_valid rst s_axis_tdata[0] s_axis_tdata[1]
+ s_axis_tdata[2] s_axis_tdata[3] s_axis_tdata[4] s_axis_tdata[5]
+ s_axis_tdata[6] s_axis_tdata[7] s_axis_tkeep s_axis_tlast
+ s_axis_tready s_axis_tuser s_axis_tvalid VSS VDD
X_0479_ _0204_ output_fcs[25] VSS VSS VDD VDD _0368_ sky130_fd_sc_hd__nand2_1
X_0480_ _0367_ _0368_ _0287_ VSS VSS VDD VDD _0027_ sky130_fd_sc_hd__a21oi_1
X_0481_ _0077_ _0149_ _0148_ VSS VSS VDD VDD _0369_ sky130_fd_sc_hd__nand3_2
X_0482_ _0150_ _0076_ _0074_ VSS VSS VDD VDD _0370_ sky130_fd_sc_hd__nand3_1
X_0483_ _0369_ _0370_ _0317_ VSS VSS VDD VDD _0371_ sky130_fd_sc_hd__a21oi_1
X_0484_ _0369_ _0370_ VSS VSS VDD VDD _0372_ sky130_fd_sc_hd__nand2_1
X_0485_ _0313_ _0312_ _0372_ VSS VSS VDD VDD _0373_ sky130_fd_sc_hd__a21oi_1
X_0486_ _0371_ _0373_ _0272_ VSS VSS VDD VDD _0374_ sky130_fd_sc_hd__o21ai_1
X_0487_ _0317_ _0370_ _0369_ VSS VSS VDD VDD _0375_ sky130_fd_sc_hd__nand3_1
X_0488_ _0314_ _0372_ VSS VSS VDD VDD _0376_ sky130_fd_sc_hd__nand2_1
X_0489_ _0266_ _0271_ _0375_ _0376_ VSS VSS VDD VDD _0377_
+ sky130_fd_sc_hd__o211ai_1
X_0490_ _0374_ _0377_ _0088_ VSS VSS VDD VDD _0378_ sky130_fd_sc_hd__nand3_1
X_0491_ _0204_ output_fcs[26] VSS VSS VDD VDD _0379_ sky130_fd_sc_hd__nand2_1
X_0492_ _0378_ _0379_ _0287_ VSS VSS VDD VDD _0028_ sky130_fd_sc_hd__a21oi_1
X_0493_ _0353_ _0354_ _0176_ VSS VSS VDD VDD _0380_ sky130_fd_sc_hd__o21ai_1
X_0494_ _0357_ _0358_ _0175_ VSS VSS VDD VDD _0381_ sky130_fd_sc_hd__nand3_1
X_0495_ _0380_ _0381_ _0088_ VSS VSS VDD VDD _0382_ sky130_fd_sc_hd__nand3_1
X_0496_ _0204_ output_fcs[27] VSS VSS VDD VDD _0383_ sky130_fd_sc_hd__nand2_1
X_0497_ _0382_ _0383_ _0287_ VSS VSS VDD VDD _0029_ sky130_fd_sc_hd__a21oi_1
X_0498_ _0168_ _0116_ VSS VSS VDD VDD _0384_ sky130_fd_sc_hd__xnor2_1
X_0499_ _0298_ _0297_ _0384_ VSS VSS VDD VDD _0385_ sky130_fd_sc_hd__a21o_1
X_0500_ _0384_ _0298_ _0297_ VSS VSS VDD VDD _0386_ sky130_fd_sc_hd__nand3_1
X_0501_ _0385_ _0386_ _0088_ VSS VSS VDD VDD _0387_ sky130_fd_sc_hd__nand3_1
X_0502_ _0092_ output_fcs[28] VSS VSS VDD VDD _0388_ sky130_fd_sc_hd__nand2_1
X_0503_ _0387_ _0388_ _0067_ VSS VSS VDD VDD _0030_ sky130_fd_sc_hd__a21oi_1
X_0504_ _0190_ _0372_ VSS VSS VDD VDD _0389_ sky130_fd_sc_hd__nor2_1
X_0505_ _0372_ _0190_ VSS VSS VDD VDD _0390_ sky130_fd_sc_hd__nand2_1
X_0506_ _0389_ _0390_ _0118_ VSS VSS VDD VDD _0391_ sky130_fd_sc_hd__nand3b_1
X_0507_ _0369_ _0370_ _0181_ VSS VSS VDD VDD _0392_ sky130_fd_sc_hd__a21oi_1
X_0508_ _0392_ _0389_ _0118_ VSS VSS VDD VDD _0393_ sky130_fd_sc_hd__o21bai_1
X_0509_ _0391_ _0393_ _0088_ VSS VSS VDD VDD _0394_ sky130_fd_sc_hd__nand3_1
X_0510_ _0092_ output_fcs[29] VSS VSS VDD VDD _0395_ sky130_fd_sc_hd__nand2_1
X_0511_ _0394_ _0395_ _0094_ VSS VSS VDD VDD _0031_ sky130_fd_sc_hd__a21oi_1
X_0512_ _0372_ _0118_ VSS VSS VDD VDD _0396_ sky130_fd_sc_hd__xnor2_1
X_0513_ _0396_ _0089_ VSS VSS VDD VDD _0397_ sky130_fd_sc_hd__nand2_1
X_0514_ _0096_ output_fcs[30] VSS VSS VDD VDD _0398_ sky130_fd_sc_hd__nand2_1
X_0515_ _0397_ _0398_ _0067_ VSS VSS VDD VDD _0032_ sky130_fd_sc_hd__a21oi_1
X_0516_ _0079_ _0101_ _0083_ VSS VSS VDD VDD _0399_ sky130_fd_sc_hd__o21ai_0
X_0517_ _0083_ _0269_ _0069_ _0399_ VSS VSS VDD VDD _0033_
+ sky130_fd_sc_hd__o211ai_1
X_0518_ _0116_ _0110_ VSS VSS VDD VDD _0400_ sky130_fd_sc_hd__xor2_1
X_0519_ s_axis_tvalid VSS VSS VDD VDD _0401_ sky130_fd_sc_hd__clkbuf_1
X_0520_ _0079_ _0400_ _0401_ VSS VSS VDD VDD _0402_ sky130_fd_sc_hd__o21ai_0
X_0521_ _0086_ VSS VSS VDD VDD _0403_ sky130_fd_sc_hd__clkbuf_1
X_0522_ _0403_ crc_state[1] VSS VSS VDD VDD _0404_ sky130_fd_sc_hd__nand2_1
X_0523_ _0068_ VSS VSS VDD VDD _0405_ sky130_fd_sc_hd__clkbuf_1
X_0524_ _0402_ _0404_ _0405_ VSS VSS VDD VDD _0034_ sky130_fd_sc_hd__nand3_1
X_0525_ _0080_ VSS VSS VDD VDD _0406_ sky130_fd_sc_hd__clkbuf_1
X_0526_ _0126_ _0127_ _0406_ VSS VSS VDD VDD _0407_ sky130_fd_sc_hd__nand3_1
X_0527_ _0083_ VSS VSS VDD VDD _0408_ sky130_fd_sc_hd__buf_1
X_0528_ _0407_ _0408_ VSS VSS VDD VDD _0409_ sky130_fd_sc_hd__nand2_1
X_0529_ _0403_ crc_state[2] VSS VSS VDD VDD _0410_ sky130_fd_sc_hd__nand2_1
X_0530_ _0409_ _0410_ _0405_ VSS VSS VDD VDD _0035_ sky130_fd_sc_hd__nand3_1
X_0531_ _0133_ _0139_ VSS VSS VDD VDD _0411_ sky130_fd_sc_hd__xnor2_1
X_0532_ _0079_ _0411_ _0401_ VSS VSS VDD VDD _0412_ sky130_fd_sc_hd__o21ai_0
X_0533_ _0403_ crc_state[3] VSS VSS VDD VDD _0413_ sky130_fd_sc_hd__nand2_1
X_0534_ _0412_ _0413_ _0405_ VSS VSS VDD VDD _0036_ sky130_fd_sc_hd__nand3_1
X_0535_ _0156_ _0159_ _0081_ VSS VSS VDD VDD _0414_ sky130_fd_sc_hd__nand3_1
X_0536_ _0414_ _0401_ VSS VSS VDD VDD _0415_ sky130_fd_sc_hd__nand2_1
X_0537_ _0083_ _0122_ _0069_ _0415_ VSS VSS VDD VDD _0037_
+ sky130_fd_sc_hd__o211ai_1
X_0538_ _0177_ _0178_ _0406_ VSS VSS VDD VDD _0416_ sky130_fd_sc_hd__nand3_1
X_0539_ _0416_ _0401_ VSS VSS VDD VDD _0417_ sky130_fd_sc_hd__nand2_1
X_0540_ _0403_ crc_state[5] VSS VSS VDD VDD _0418_ sky130_fd_sc_hd__nand2_1
X_0541_ _0417_ _0418_ _0405_ VSS VSS VDD VDD _0038_ sky130_fd_sc_hd__nand3_1
X_0542_ _0240_ _0182_ VSS VSS VDD VDD _0419_ sky130_fd_sc_hd__xor2_1
X_0543_ _0079_ _0419_ _0401_ VSS VSS VDD VDD _0420_ sky130_fd_sc_hd__o21ai_0
X_0544_ _0403_ crc_state[6] VSS VSS VDD VDD _0421_ sky130_fd_sc_hd__nand2_1
X_0545_ _0420_ _0421_ _0405_ VSS VSS VDD VDD _0039_ sky130_fd_sc_hd__nand3_1
X_0546_ _0193_ _0194_ _0081_ VSS VSS VDD VDD _0422_ sky130_fd_sc_hd__nand3_1
X_0547_ _0422_ _0084_ VSS VSS VDD VDD _0423_ sky130_fd_sc_hd__nand2_1
X_0548_ _0075_ _0083_ _0069_ _0423_ VSS VSS VDD VDD _0040_
+ sky130_fd_sc_hd__o211ai_1
X_0549_ _0201_ _0202_ _0406_ VSS VSS VDD VDD _0424_ sky130_fd_sc_hd__nand3_1
X_0550_ _0424_ _0408_ VSS VSS VDD VDD _0425_ sky130_fd_sc_hd__nand2_1
X_0551_ _0403_ crc_0__eth_crc_inst_state_bits_0__with_shifted_state_network_tail
+ VSS VSS VDD VDD _0426_ sky130_fd_sc_hd__nand2_1
X_0552_ _0425_ _0426_ _0405_ VSS VSS VDD VDD _0041_ sky130_fd_sc_hd__nand3_1
X_0553_ _0068_ VSS VSS VDD VDD _0427_ sky130_fd_sc_hd__clkbuf_1
X_0554_ _0079_ _0206_ _0083_ VSS VSS VDD VDD _0428_ sky130_fd_sc_hd__o21ai_0
X_0555_ _0105_ _0066_ _0427_ _0428_ VSS VSS VDD VDD _0042_
+ sky130_fd_sc_hd__o211ai_1
X_0556_ _0079_ _0209_ _0083_ VSS VSS VDD VDD _0429_ sky130_fd_sc_hd__o21ai_0
X_0557_ _0119_ _0066_ _0427_ _0429_ VSS VSS VDD VDD _0043_
+ sky130_fd_sc_hd__o211ai_1
X_0558_ _0079_ _0212_ _0083_ VSS VSS VDD VDD _0430_ sky130_fd_sc_hd__o21ai_0
X_0559_ _0134_ _0084_ _0427_ _0430_ VSS VSS VDD VDD _0044_
+ sky130_fd_sc_hd__o211ai_1
X_0560_ _0217_ _0218_ _0081_ VSS VSS VDD VDD _0431_ sky130_fd_sc_hd__nand3_1
X_0561_ _0431_ _0084_ VSS VSS VDD VDD _0432_ sky130_fd_sc_hd__nand2_1
X_0562_ _0151_ _0084_ _0427_ _0432_ VSS VSS VDD VDD _0045_
+ sky130_fd_sc_hd__o211ai_1
X_0563_ _0118_ _0222_ VSS VSS VDD VDD _0433_ sky130_fd_sc_hd__xnor2_1
X_0564_ _0079_ _0433_ _0401_ VSS VSS VDD VDD _0434_ sky130_fd_sc_hd__o21ai_0
X_0565_ _0403_ crc_0__eth_crc_inst_state_bits_5__with_shifted_state_network_tail
+ VSS VSS VDD VDD _0435_ sky130_fd_sc_hd__nand2_1
X_0566_ _0434_ _0435_ _0427_ VSS VSS VDD VDD _0046_ sky130_fd_sc_hd__nand3_1
X_0567_ _0133_ _0227_ VSS VSS VDD VDD _0436_ sky130_fd_sc_hd__xnor2_1
X_0568_ _0079_ _0436_ _0401_ VSS VSS VDD VDD _0437_ sky130_fd_sc_hd__o21ai_0
X_0569_ _0403_ crc_0__eth_crc_inst_state_bits_6__with_shifted_state_network_tail
+ VSS VSS VDD VDD _0438_ sky130_fd_sc_hd__nand2_1
X_0570_ _0437_ _0438_ _0405_ VSS VSS VDD VDD _0047_ sky130_fd_sc_hd__nand3_1
X_0571_ _0236_ _0237_ _0080_ VSS VSS VDD VDD _0439_ sky130_fd_sc_hd__nand3_1
X_0572_ _0439_ _0084_ VSS VSS VDD VDD _0440_ sky130_fd_sc_hd__nand2_1
X_0573_ _0186_ _0066_ _0069_ _0440_ VSS VSS VDD VDD _0048_
+ sky130_fd_sc_hd__o211ai_1
X_0574_ _0248_ _0249_ _0406_ VSS VSS VDD VDD _0441_ sky130_fd_sc_hd__nand3_1
X_0575_ _0441_ _0408_ VSS VSS VDD VDD _0442_ sky130_fd_sc_hd__nand2_1
X_0576_ _0403_ crc_0__eth_crc_inst_state_bits_8__with_shifted_state_network_tail
+ VSS VSS VDD VDD _0443_ sky130_fd_sc_hd__nand2_1
X_0577_ _0442_ _0443_ _0427_ VSS VSS VDD VDD _0049_ sky130_fd_sc_hd__nand3_1
X_0578_ _0260_ _0263_ _0081_ VSS VSS VDD VDD _0444_ sky130_fd_sc_hd__nand3_1
X_0579_ _0444_ _0408_ VSS VSS VDD VDD _0445_ sky130_fd_sc_hd__nand2_1
X_0580_ _0086_ crc_0__eth_crc_inst_state_bits_9__with_shifted_state_network_tail
+ VSS VSS VDD VDD _0446_ sky130_fd_sc_hd__nand2_1
X_0581_ _0445_ _0446_ _0427_ VSS VSS VDD VDD _0050_ sky130_fd_sc_hd__nand3_1
X_0582_ _0283_ _0284_ _0081_ VSS VSS VDD VDD _0447_ sky130_fd_sc_hd__nand3_1
X_0583_ _0447_ _0408_ VSS VSS VDD VDD _0448_ sky130_fd_sc_hd__nand2_1
X_0584_ _0086_ crc_0__eth_crc_inst_state_bits_10__with_shifted_state_network_tail
+ VSS VSS VDD VDD _0449_ sky130_fd_sc_hd__nand2_1
X_0585_ _0448_ _0449_ _0427_ VSS VSS VDD VDD _0051_ sky130_fd_sc_hd__nand3_1
X_0586_ _0303_ _0304_ _0406_ VSS VSS VDD VDD _0450_ sky130_fd_sc_hd__nand3_1
X_0587_ _0450_ _0408_ VSS VSS VDD VDD _0451_ sky130_fd_sc_hd__nand2_1
X_0588_ _0086_ crc_0__eth_crc_inst_state_bits_11__with_shifted_state_network_tail
+ VSS VSS VDD VDD _0452_ sky130_fd_sc_hd__nand2_1
X_0589_ _0451_ _0452_ _0427_ VSS VSS VDD VDD _0052_ sky130_fd_sc_hd__nand3_1
X_0590_ _0315_ _0318_ _0081_ VSS VSS VDD VDD _0453_ sky130_fd_sc_hd__nand3_1
X_0591_ _0453_ _0084_ VSS VSS VDD VDD _0454_ sky130_fd_sc_hd__nand2_1
X_0592_ _0215_ _0066_ _0069_ _0454_ VSS VSS VDD VDD _0053_
+ sky130_fd_sc_hd__o211ai_1
X_0593_ _0327_ _0329_ _0080_ VSS VSS VDD VDD _0455_ sky130_fd_sc_hd__nand3_1
X_0594_ _0455_ _0401_ VSS VSS VDD VDD _0456_ sky130_fd_sc_hd__nand2_1
X_0595_ _0221_ _0066_ _0069_ _0456_ VSS VSS VDD VDD _0054_
+ sky130_fd_sc_hd__o211ai_1
X_0596_ _0337_ _0339_ _0081_ VSS VSS VDD VDD _0457_ sky130_fd_sc_hd__nand3_1
X_0597_ _0457_ _0401_ VSS VSS VDD VDD _0458_ sky130_fd_sc_hd__nand2_1
X_0598_ _0226_ _0066_ _0069_ _0458_ VSS VSS VDD VDD _0055_
+ sky130_fd_sc_hd__o211ai_1
X_0599_ _0346_ _0348_ _0081_ VSS VSS VDD VDD _0459_ sky130_fd_sc_hd__nand3_1
X_0600_ _0459_ _0084_ VSS VSS VDD VDD _0460_ sky130_fd_sc_hd__nand2_1
X_0601_ _0234_ _0066_ _0069_ _0460_ VSS VSS VDD VDD _0056_
+ sky130_fd_sc_hd__o211ai_1
X_0602_ _0355_ _0359_ _0406_ VSS VSS VDD VDD _0461_ sky130_fd_sc_hd__nand3_1
X_0603_ _0461_ _0408_ VSS VSS VDD VDD _0462_ sky130_fd_sc_hd__nand2_1
X_0604_ _0086_ crc_0__eth_crc_inst_state_bits_16__with_shifted_state_network_tail
+ VSS VSS VDD VDD _0463_ sky130_fd_sc_hd__nand2_1
X_0605_ _0462_ _0463_ _0405_ VSS VSS VDD VDD _0057_ sky130_fd_sc_hd__nand3_1
X_0606_ _0365_ _0366_ _0406_ VSS VSS VDD VDD _0464_ sky130_fd_sc_hd__nand3_1
X_0607_ _0464_ _0408_ VSS VSS VDD VDD _0465_ sky130_fd_sc_hd__nand2_1
X_0608_ _0086_ crc_0__eth_crc_inst_state_bits_17__with_shifted_state_network_tail
+ VSS VSS VDD VDD _0466_ sky130_fd_sc_hd__nand2_1
X_0609_ _0465_ _0466_ _0405_ VSS VSS VDD VDD _0058_ sky130_fd_sc_hd__nand3_1
X_0610_ _0374_ _0377_ _0406_ VSS VSS VDD VDD _0467_ sky130_fd_sc_hd__nand3_1
X_0611_ _0467_ _0408_ VSS VSS VDD VDD _0468_ sky130_fd_sc_hd__nand2_1
X_0612_ _0086_ crc_0__eth_crc_inst_state_bits_18__with_shifted_state_network_tail
+ VSS VSS VDD VDD _0469_ sky130_fd_sc_hd__nand2_1
X_0613_ _0468_ _0469_ _0405_ VSS VSS VDD VDD _0059_ sky130_fd_sc_hd__nand3_1
X_0614_ _0380_ _0381_ _0406_ VSS VSS VDD VDD _0470_ sky130_fd_sc_hd__nand3_1
X_0615_ _0470_ _0408_ VSS VSS VDD VDD _0471_ sky130_fd_sc_hd__nand2_1
X_0616_ _0086_ crc_0__eth_crc_inst_state_bits_19__with_shifted_state_network_tail
+ VSS VSS VDD VDD _0472_ sky130_fd_sc_hd__nand2_1
X_0617_ _0471_ _0472_ _0427_ VSS VSS VDD VDD _0060_ sky130_fd_sc_hd__nand3_1
X_0618_ _0385_ _0386_ _0080_ VSS VSS VDD VDD _0473_ sky130_fd_sc_hd__nand3_1
X_0619_ _0473_ _0401_ VSS VSS VDD VDD _0474_ sky130_fd_sc_hd__nand2_1
X_0620_ _0308_ _0066_ _0069_ _0474_ VSS VSS VDD VDD _0061_
+ sky130_fd_sc_hd__o211ai_1
X_0621_ _0391_ _0393_ _0080_ VSS VSS VDD VDD _0475_ sky130_fd_sc_hd__nand3_1
X_0622_ _0475_ _0084_ VSS VSS VDD VDD _0476_ sky130_fd_sc_hd__nand2_1
X_0623_ _0322_ _0066_ _0068_ _0476_ VSS VSS VDD VDD _0062_
+ sky130_fd_sc_hd__o211ai_1
X_0624_ _0396_ _0081_ VSS VSS VDD VDD _0477_ sky130_fd_sc_hd__nand2_1
X_0625_ _0477_ _0084_ VSS VSS VDD VDD _0478_ sky130_fd_sc_hd__nand2_1
X_0626_ _0083_ _0333_ _0068_ _0478_ VSS VSS VDD VDD _0063_
+ sky130_fd_sc_hd__o211ai_1
X_0627_ _0067_ _0406_ _0403_ VSS VSS VDD VDD _0064_ sky130_fd_sc_hd__nor3_1
X_0628_ crc_0__eth_crc_inst_state_bits_23__with_shifted_state_network_tail
+ VSS VSS VDD VDD _0065_ sky130_fd_sc_hd__inv_1
X_0629_ s_axis_tvalid VSS VSS VDD VDD _0066_ sky130_fd_sc_hd__clkbuf_1
X_0630_ rst VSS VSS VDD VDD _0067_ sky130_fd_sc_hd__clkbuf_1
X_0631_ _0067_ VSS VSS VDD VDD _0068_ sky130_fd_sc_hd__inv_1
X_0632_ _0068_ VSS VSS VDD VDD _0069_ sky130_fd_sc_hd__clkbuf_1
X_0633_ s_axis_tdata[1] crc_state[1] VSS VSS VDD VDD _0070_
+ sky130_fd_sc_hd__nand2b_1
X_0634_ crc_state[1] s_axis_tdata[1] VSS VSS VDD VDD _0071_
+ sky130_fd_sc_hd__nand2b_1
X_0635_ _0070_ _0071_ VSS VSS VDD VDD _0072_ sky130_fd_sc_hd__nand2_2
X_0636_ s_axis_tdata[7] VSS VSS VDD VDD _0073_ sky130_fd_sc_hd__inv_1
X_0637_ _0073_ crc_state[7] VSS VSS VDD VDD _0074_ sky130_fd_sc_hd__nand2_1
X_0638_ crc_state[7] VSS VSS VDD VDD _0075_ sky130_fd_sc_hd__inv_1
X_0639_ _0075_ s_axis_tdata[7] VSS VSS VDD VDD _0076_ sky130_fd_sc_hd__nand2_1
X_0640_ _0074_ _0076_ VSS VSS VDD VDD _0077_ sky130_fd_sc_hd__nand2_2
X_0641_ _0072_ _0077_ VSS VSS VDD VDD _0078_ sky130_fd_sc_hd__xnor2_1
X_0642_ s_axis_tlast VSS VSS VDD VDD _0079_ sky130_fd_sc_hd__clkbuf_2
X_0643_ _0079_ VSS VSS VDD VDD _0080_ sky130_fd_sc_hd__inv_1
X_0644_ _0080_ VSS VSS VDD VDD _0081_ sky130_fd_sc_hd__clkbuf_1
X_0645_ _0078_ _0081_ VSS VSS VDD VDD _0082_ sky130_fd_sc_hd__nand2_1
X_0646_ s_axis_tvalid VSS VSS VDD VDD _0083_ sky130_fd_sc_hd__clkbuf_1
X_0647_ _0083_ VSS VSS VDD VDD _0084_ sky130_fd_sc_hd__clkbuf_1
X_0648_ _0082_ _0084_ VSS VSS VDD VDD _0085_ sky130_fd_sc_hd__nand2_1
X_0649_ _0065_ _0066_ _0069_ _0085_ VSS VSS VDD VDD _0000_
+ sky130_fd_sc_hd__o211ai_1
X_0650_ s_axis_tvalid VSS VSS VDD VDD _0086_ sky130_fd_sc_hd__clkinv_1
X_0651_ _0086_ _0080_ VSS VSS VDD VDD _0087_ sky130_fd_sc_hd__nor2_1
X_0652_ _0087_ VSS VSS VDD VDD _0088_ sky130_fd_sc_hd__buf_2
X_0653_ _0088_ VSS VSS VDD VDD _0089_ sky130_fd_sc_hd__buf_2
X_0654_ _0078_ _0089_ VSS VSS VDD VDD _0090_ sky130_fd_sc_hd__nand2_1
X_0655_ _0087_ VSS VSS VDD VDD _0091_ sky130_fd_sc_hd__inv_2
X_0656_ _0091_ VSS VSS VDD VDD _0092_ sky130_fd_sc_hd__clkbuf_1
X_0657_ _0092_ output_fcs[31] VSS VSS VDD VDD _0093_ sky130_fd_sc_hd__nand2_1
X_0658_ _0067_ VSS VSS VDD VDD _0094_ sky130_fd_sc_hd__clkbuf_1
X_0659_ _0090_ _0093_ _0094_ VSS VSS VDD VDD _0001_ sky130_fd_sc_hd__a21oi_1
X_0660_ _0067_ VSS VSS VDD VDD _0095_ sky130_fd_sc_hd__clkbuf_1
X_0661_ _0091_ VSS VSS VDD VDD _0096_ sky130_fd_sc_hd__clkbuf_1
X_0662_ s_axis_tdata[2] VSS VSS VDD VDD _0097_ sky130_fd_sc_hd__inv_1
X_0663_ _0097_ crc_state[2] VSS VSS VDD VDD _0098_ sky130_fd_sc_hd__nand2_1
X_0664_ crc_state[2] s_axis_tdata[2] VSS VSS VDD VDD _0099_
+ sky130_fd_sc_hd__nand2b_1
X_0665_ _0098_ _0099_ VSS VSS VDD VDD _0100_ sky130_fd_sc_hd__nand2_2
X_0666_ crc_0__eth_crc_inst_state_bits_0__with_shifted_state_network_tail
+ _0100_ VSS VSS VDD VDD _0101_ sky130_fd_sc_hd__xor2_1
X_0667_ _0091_ output_fcs[0] VSS VSS VDD VDD _0102_ sky130_fd_sc_hd__nand2_1
X_0668_ _0096_ _0101_ _0102_ VSS VSS VDD VDD _0103_ sky130_fd_sc_hd__o21a_1
X_0669_ _0095_ _0103_ VSS VSS VDD VDD _0002_ sky130_fd_sc_hd__nor2_1
X_0670_ s_axis_tdata[0] crc_state[0] VSS VSS VDD VDD _0104_
+ sky130_fd_sc_hd__xor2_4
X_0671_ crc_0__eth_crc_inst_state_bits_1__with_shifted_state_network_tail
+ VSS VSS VDD VDD _0105_ sky130_fd_sc_hd__inv_1
X_0672_ s_axis_tdata[3] VSS VSS VDD VDD _0106_ sky130_fd_sc_hd__inv_1
X_0673_ _0106_ crc_state[3] VSS VSS VDD VDD _0107_ sky130_fd_sc_hd__nand2_1
X_0674_ crc_state[3] s_axis_tdata[3] VSS VSS VDD VDD _0108_
+ sky130_fd_sc_hd__nand2b_1
X_0675_ _0107_ _0108_ VSS VSS VDD VDD _0109_ sky130_fd_sc_hd__nand2_2
X_0676_ _0105_ _0109_ VSS VSS VDD VDD _0110_ sky130_fd_sc_hd__xor2_1
X_0677_ _0104_ _0110_ VSS VSS VDD VDD _0111_ sky130_fd_sc_hd__xor2_1
X_0678_ _0111_ _0089_ VSS VSS VDD VDD _0112_ sky130_fd_sc_hd__nand2_1
X_0679_ _0092_ output_fcs[1] VSS VSS VDD VDD _0113_ sky130_fd_sc_hd__nand2_1
X_0680_ _0112_ _0113_ _0094_ VSS VSS VDD VDD _0003_ sky130_fd_sc_hd__a21oi_1
X_0681_ s_axis_tdata[1] crc_state[1] VSS VSS VDD VDD _0114_
+ sky130_fd_sc_hd__xnor2_1
X_0682_ _0104_ _0114_ VSS VSS VDD VDD _0115_ sky130_fd_sc_hd__nand2_1
X_0683_ s_axis_tdata[0] crc_state[0] VSS VSS VDD VDD _0116_
+ sky130_fd_sc_hd__xnor2_2
X_0684_ _0116_ _0072_ VSS VSS VDD VDD _0117_ sky130_fd_sc_hd__nand2_1
X_0685_ _0115_ _0117_ VSS VSS VDD VDD _0118_ sky130_fd_sc_hd__nand2_2
X_0686_ crc_0__eth_crc_inst_state_bits_2__with_shifted_state_network_tail
+ VSS VSS VDD VDD _0119_ sky130_fd_sc_hd__inv_1
X_0687_ s_axis_tdata[4] VSS VSS VDD VDD _0120_ sky130_fd_sc_hd__inv_1
X_0688_ _0120_ crc_state[4] VSS VSS VDD VDD _0121_ sky130_fd_sc_hd__nand2_1
X_0689_ crc_state[4] VSS VSS VDD VDD _0122_ sky130_fd_sc_hd__inv_2
X_0690_ _0122_ s_axis_tdata[4] VSS VSS VDD VDD _0123_ sky130_fd_sc_hd__nand2_1
X_0691_ _0121_ _0123_ VSS VSS VDD VDD _0124_ sky130_fd_sc_hd__nand2_1
X_0692_ _0119_ _0124_ VSS VSS VDD VDD _0125_ sky130_fd_sc_hd__xor2_1
X_0693_ _0118_ _0125_ VSS VSS VDD VDD _0126_ sky130_fd_sc_hd__or2_1
X_0694_ _0125_ _0118_ VSS VSS VDD VDD _0127_ sky130_fd_sc_hd__nand2_1
X_0695_ _0088_ VSS VSS VDD VDD _0128_ sky130_fd_sc_hd__buf_2
X_0696_ _0126_ _0127_ _0128_ VSS VSS VDD VDD _0129_ sky130_fd_sc_hd__nand3_1
X_0697_ _0092_ output_fcs[2] VSS VSS VDD VDD _0130_ sky130_fd_sc_hd__nand2_1
X_0698_ _0129_ _0130_ _0094_ VSS VSS VDD VDD _0004_ sky130_fd_sc_hd__a21oi_1
X_0699_ _0114_ _0100_ VSS VSS VDD VDD _0131_ sky130_fd_sc_hd__nand2_1
X_0700_ _0072_ _0099_ _0098_ VSS VSS VDD VDD _0132_ sky130_fd_sc_hd__nand3_1
X_0701_ _0131_ _0132_ VSS VSS VDD VDD _0133_ sky130_fd_sc_hd__nand2_1
X_0702_ crc_0__eth_crc_inst_state_bits_3__with_shifted_state_network_tail
+ VSS VSS VDD VDD _0134_ sky130_fd_sc_hd__inv_1
X_0703_ s_axis_tdata[5] VSS VSS VDD VDD _0135_ sky130_fd_sc_hd__inv_1
X_0704_ _0135_ crc_state[5] VSS VSS VDD VDD _0136_ sky130_fd_sc_hd__nand2_2
X_0705_ crc_state[5] s_axis_tdata[5] VSS VSS VDD VDD _0137_
+ sky130_fd_sc_hd__nand2b_4
X_0706_ _0136_ _0137_ VSS VSS VDD VDD _0138_ sky130_fd_sc_hd__nand2_2
X_0707_ _0134_ _0138_ VSS VSS VDD VDD _0139_ sky130_fd_sc_hd__xor2_1
X_0708_ _0133_ _0139_ VSS VSS VDD VDD _0140_ sky130_fd_sc_hd__xor2_1
X_0709_ _0140_ _0089_ VSS VSS VDD VDD _0141_ sky130_fd_sc_hd__nand2_1
X_0710_ _0092_ output_fcs[3] VSS VSS VDD VDD _0142_ sky130_fd_sc_hd__nand2_1
X_0711_ _0141_ _0142_ _0095_ VSS VSS VDD VDD _0005_ sky130_fd_sc_hd__a21oi_1
X_0712_ s_axis_tdata[6] crc_state[6] VSS VSS VDD VDD _0143_
+ sky130_fd_sc_hd__nor2b_1
X_0713_ s_axis_tdata[6] VSS VSS VDD VDD _0144_ sky130_fd_sc_hd__inv_2
X_0714_ crc_state[6] _0144_ VSS VSS VDD VDD _0145_ sky130_fd_sc_hd__nor2_1
X_0715_ _0143_ _0145_ VSS VSS VDD VDD _0146_ sky130_fd_sc_hd__nor2_1
X_0716_ _0146_ crc_0__eth_crc_inst_state_bits_4__with_shifted_state_network_tail
+ VSS VSS VDD VDD _0147_ sky130_fd_sc_hd__nand2_1
X_0717_ _0144_ crc_state[6] VSS VSS VDD VDD _0148_ sky130_fd_sc_hd__nand2_1
X_0718_ crc_state[6] s_axis_tdata[6] VSS VSS VDD VDD _0149_
+ sky130_fd_sc_hd__nand2b_4
X_0719_ _0148_ _0149_ VSS VSS VDD VDD _0150_ sky130_fd_sc_hd__nand2_2
X_0720_ crc_0__eth_crc_inst_state_bits_4__with_shifted_state_network_tail
+ VSS VSS VDD VDD _0151_ sky130_fd_sc_hd__inv_1
X_0721_ _0150_ _0151_ VSS VSS VDD VDD _0152_ sky130_fd_sc_hd__nand2_1
X_0722_ _0147_ _0152_ _0109_ VSS VSS VDD VDD _0153_ sky130_fd_sc_hd__a21oi_1
X_0723_ _0147_ _0109_ _0152_ VSS VSS VDD VDD _0154_ sky130_fd_sc_hd__and3_1
X_0724_ _0100_ _0104_ VSS VSS VDD VDD _0155_ sky130_fd_sc_hd__xnor2_1
X_0725_ _0153_ _0154_ _0155_ VSS VSS VDD VDD _0156_ sky130_fd_sc_hd__o21ai_1
X_0726_ _0147_ _0152_ _0109_ VSS VSS VDD VDD _0157_ sky130_fd_sc_hd__nand3_1
X_0727_ _0100_ _0116_ VSS VSS VDD VDD _0158_ sky130_fd_sc_hd__xnor2_1
X_0728_ _0153_ _0157_ _0158_ VSS VSS VDD VDD _0159_ sky130_fd_sc_hd__nand3b_1
X_0729_ _0156_ _0159_ _0128_ VSS VSS VDD VDD _0160_ sky130_fd_sc_hd__nand3_1
X_0730_ _0092_ output_fcs[4] VSS VSS VDD VDD _0161_ sky130_fd_sc_hd__nand2_1
X_0731_ _0160_ _0161_ _0095_ VSS VSS VDD VDD _0006_ sky130_fd_sc_hd__a21oi_1
X_0732_ s_axis_tdata[7] crc_state[7] VSS VSS VDD VDD _0162_
+ sky130_fd_sc_hd__nor2b_1
X_0733_ crc_state[7] _0073_ VSS VSS VDD VDD _0163_ sky130_fd_sc_hd__nor2_1
X_0734_ _0162_ _0163_ VSS VSS VDD VDD _0164_ sky130_fd_sc_hd__nor2_1
X_0735_ _0164_ crc_0__eth_crc_inst_state_bits_5__with_shifted_state_network_tail
+ VSS VSS VDD VDD _0165_ sky130_fd_sc_hd__nand2_1
X_0736_ crc_0__eth_crc_inst_state_bits_5__with_shifted_state_network_tail
+ VSS VSS VDD VDD _0166_ sky130_fd_sc_hd__inv_1
X_0737_ _0077_ _0166_ VSS VSS VDD VDD _0167_ sky130_fd_sc_hd__nand2_1
X_0738_ _0124_ VSS VSS VDD VDD _0168_ sky130_fd_sc_hd__buf_2
X_0739_ _0165_ _0167_ _0168_ VSS VSS VDD VDD _0169_ sky130_fd_sc_hd__a21oi_1
X_0740_ _0165_ _0167_ _0168_ VSS VSS VDD VDD _0170_ sky130_fd_sc_hd__nand3_1
X_0741_ _0170_ VSS VSS VDD VDD _0171_ sky130_fd_sc_hd__inv_1
X_0742_ _0107_ _0108_ VSS VSS VDD VDD _0172_ sky130_fd_sc_hd__and2_1
X_0743_ _0172_ _0072_ VSS VSS VDD VDD _0173_ sky130_fd_sc_hd__nand2_1
X_0744_ _0114_ _0109_ VSS VSS VDD VDD _0174_ sky130_fd_sc_hd__nand2_1
X_0745_ _0173_ _0174_ VSS VSS VDD VDD _0175_ sky130_fd_sc_hd__nand2_1
X_0746_ _0175_ VSS VSS VDD VDD _0176_ sky130_fd_sc_hd__inv_1
X_0747_ _0169_ _0171_ _0176_ VSS VSS VDD VDD _0177_ sky130_fd_sc_hd__o21ai_0
X_0748_ _0169_ _0170_ _0175_ VSS VSS VDD VDD _0178_ sky130_fd_sc_hd__nand3b_1
X_0749_ _0177_ _0178_ _0128_ VSS VSS VDD VDD _0179_ sky130_fd_sc_hd__nand3_1
X_0750_ _0092_ output_fcs[5] VSS VSS VDD VDD _0180_ sky130_fd_sc_hd__nand2_1
X_0751_ _0179_ _0180_ _0095_ VSS VSS VDD VDD _0007_ sky130_fd_sc_hd__a21oi_1
X_0752_ _0138_ VSS VSS VDD VDD _0181_ sky130_fd_sc_hd__buf_6
X_0753_ crc_0__eth_crc_inst_state_bits_6__with_shifted_state_network_tail
+ _0181_ VSS VSS VDD VDD _0182_ sky130_fd_sc_hd__xnor2_1
X_0754_ _0168_ _0182_ VSS VSS VDD VDD _0183_ sky130_fd_sc_hd__xor2_1
X_0755_ _0183_ _0089_ VSS VSS VDD VDD _0184_ sky130_fd_sc_hd__nand2_1
X_0756_ _0092_ output_fcs[6] VSS VSS VDD VDD _0185_ sky130_fd_sc_hd__nand2_1
X_0757_ _0184_ _0185_ _0095_ VSS VSS VDD VDD _0008_ sky130_fd_sc_hd__a21oi_1
X_0758_ crc_0__eth_crc_inst_state_bits_7__with_shifted_state_network_tail
+ VSS VSS VDD VDD _0186_ sky130_fd_sc_hd__inv_1
X_0759_ _0150_ VSS VSS VDD VDD _0187_ sky130_fd_sc_hd__buf_4
X_0760_ _0186_ _0187_ VSS VSS VDD VDD _0188_ sky130_fd_sc_hd__xor2_1
X_0761_ _0138_ _0116_ VSS VSS VDD VDD _0189_ sky130_fd_sc_hd__nor2_1
X_0762_ _0136_ _0137_ VSS VSS VDD VDD _0190_ sky130_fd_sc_hd__and2_1
X_0763_ _0104_ _0190_ VSS VSS VDD VDD _0191_ sky130_fd_sc_hd__nor2_1
X_0764_ _0189_ _0191_ VSS VSS VDD VDD _0192_ sky130_fd_sc_hd__nor2_1
X_0765_ _0188_ _0192_ VSS VSS VDD VDD _0193_ sky130_fd_sc_hd__nand2b_1
X_0766_ _0189_ _0191_ _0188_ VSS VSS VDD VDD _0194_ sky130_fd_sc_hd__o21ai_0
X_0767_ _0193_ _0194_ _0089_ VSS VSS VDD VDD _0195_ sky130_fd_sc_hd__nand3_1
X_0768_ _0092_ output_fcs[7] VSS VSS VDD VDD _0196_ sky130_fd_sc_hd__nand2_1
X_0769_ _0195_ _0196_ _0095_ VSS VSS VDD VDD _0009_ sky130_fd_sc_hd__a21oi_1
X_0770_ crc_0__eth_crc_inst_state_bits_8__with_shifted_state_network_tail
+ _0077_ VSS VSS VDD VDD _0197_ sky130_fd_sc_hd__xnor2_1
X_0771_ _0187_ _0114_ VSS VSS VDD VDD _0198_ sky130_fd_sc_hd__nor2_1
X_0772_ _0072_ _0146_ VSS VSS VDD VDD _0199_ sky130_fd_sc_hd__nor2_1
X_0773_ _0198_ _0199_ VSS VSS VDD VDD _0200_ sky130_fd_sc_hd__nor2_1
X_0774_ _0197_ _0200_ VSS VSS VDD VDD _0201_ sky130_fd_sc_hd__nand2b_1
X_0775_ _0198_ _0199_ _0197_ VSS VSS VDD VDD _0202_ sky130_fd_sc_hd__o21ai_0
X_0776_ _0201_ _0202_ _0089_ VSS VSS VDD VDD _0203_ sky130_fd_sc_hd__nand3_1
X_0777_ _0091_ VSS VSS VDD VDD _0204_ sky130_fd_sc_hd__clkbuf_1
X_0778_ _0204_ output_fcs[8] VSS VSS VDD VDD _0205_ sky130_fd_sc_hd__nand2_1
X_0779_ _0203_ _0205_ _0095_ VSS VSS VDD VDD _0010_ sky130_fd_sc_hd__a21oi_1
X_0780_ crc_0__eth_crc_inst_state_bits_9__with_shifted_state_network_tail
+ _0077_ VSS VSS VDD VDD _0206_ sky130_fd_sc_hd__xor2_1
X_0781_ _0091_ output_fcs[9] VSS VSS VDD VDD _0207_ sky130_fd_sc_hd__nand2_1
X_0782_ _0091_ _0206_ _0207_ VSS VSS VDD VDD _0208_ sky130_fd_sc_hd__o21a_1
X_0783_ _0095_ _0208_ VSS VSS VDD VDD _0011_ sky130_fd_sc_hd__nor2_1
X_0784_ crc_0__eth_crc_inst_state_bits_10__with_shifted_state_network_tail
+ _0100_ VSS VSS VDD VDD _0209_ sky130_fd_sc_hd__xor2_1
X_0785_ _0091_ output_fcs[10] VSS VSS VDD VDD _0210_ sky130_fd_sc_hd__nand2_1
X_0786_ _0096_ _0209_ _0210_ VSS VSS VDD VDD _0211_ sky130_fd_sc_hd__o21a_1
X_0787_ _0095_ _0211_ VSS VSS VDD VDD _0012_ sky130_fd_sc_hd__nor2_1
X_0788_ crc_0__eth_crc_inst_state_bits_11__with_shifted_state_network_tail
+ _0109_ VSS VSS VDD VDD _0212_ sky130_fd_sc_hd__xor2_1
X_0789_ _0091_ output_fcs[11] VSS VSS VDD VDD _0213_ sky130_fd_sc_hd__nand2_1
X_0790_ _0091_ _0212_ _0213_ VSS VSS VDD VDD _0214_ sky130_fd_sc_hd__o21a_1
X_0791_ _0095_ _0214_ VSS VSS VDD VDD _0013_ sky130_fd_sc_hd__nor2_1
X_0792_ crc_0__eth_crc_inst_state_bits_12__with_shifted_state_network_tail
+ VSS VSS VDD VDD _0215_ sky130_fd_sc_hd__inv_1
X_0793_ _0215_ _0124_ VSS VSS VDD VDD _0216_ sky130_fd_sc_hd__xor2_1
X_0794_ _0104_ _0216_ VSS VSS VDD VDD _0217_ sky130_fd_sc_hd__or2_2
X_0795_ _0216_ _0104_ VSS VSS VDD VDD _0218_ sky130_fd_sc_hd__nand2_1
X_0796_ _0217_ _0218_ _0089_ VSS VSS VDD VDD _0219_ sky130_fd_sc_hd__nand3_1
X_0797_ _0204_ output_fcs[12] VSS VSS VDD VDD _0220_ sky130_fd_sc_hd__nand2_1
X_0798_ _0219_ _0220_ _0094_ VSS VSS VDD VDD _0014_ sky130_fd_sc_hd__a21oi_1
X_0799_ crc_0__eth_crc_inst_state_bits_13__with_shifted_state_network_tail
+ VSS VSS VDD VDD _0221_ sky130_fd_sc_hd__inv_1
X_0800_ _0221_ _0181_ VSS VSS VDD VDD _0222_ sky130_fd_sc_hd__xor2_1
X_0801_ _0118_ _0222_ VSS VSS VDD VDD _0223_ sky130_fd_sc_hd__xor2_1
X_0802_ _0223_ _0089_ VSS VSS VDD VDD _0224_ sky130_fd_sc_hd__nand2_1
X_0803_ _0204_ output_fcs[13] VSS VSS VDD VDD _0225_ sky130_fd_sc_hd__nand2_1
X_0804_ _0224_ _0225_ _0094_ VSS VSS VDD VDD _0015_ sky130_fd_sc_hd__a21oi_1
X_0805_ crc_0__eth_crc_inst_state_bits_14__with_shifted_state_network_tail
+ VSS VSS VDD VDD _0226_ sky130_fd_sc_hd__inv_1
X_0806_ _0226_ _0187_ VSS VSS VDD VDD _0227_ sky130_fd_sc_hd__xor2_1
X_0807_ _0133_ _0227_ VSS VSS VDD VDD _0228_ sky130_fd_sc_hd__xor2_1
X_0808_ _0228_ _0089_ VSS VSS VDD VDD _0229_ sky130_fd_sc_hd__nand2_1
X_0809_ _0204_ output_fcs[14] VSS VSS VDD VDD _0230_ sky130_fd_sc_hd__nand2_1
X_0810_ _0229_ _0230_ _0094_ VSS VSS VDD VDD _0016_ sky130_fd_sc_hd__a21oi_1
X_0811_ _0109_ _0099_ _0098_ VSS VSS VDD VDD _0231_ sky130_fd_sc_hd__nand3_1
X_0812_ _0100_ _0108_ _0107_ VSS VSS VDD VDD _0232_ sky130_fd_sc_hd__nand3_1
X_0813_ _0231_ _0232_ VSS VSS VDD VDD _0233_ sky130_fd_sc_hd__nand2_1
X_0814_ crc_0__eth_crc_inst_state_bits_15__with_shifted_state_network_tail
+ VSS VSS VDD VDD _0234_ sky130_fd_sc_hd__inv_1
X_0815_ _0234_ _0077_ VSS VSS VDD VDD _0235_ sky130_fd_sc_hd__xor2_1
X_0816_ _0233_ _0235_ VSS VSS VDD VDD _0236_ sky130_fd_sc_hd__or2_2
X_0817_ _0235_ _0233_ VSS VSS VDD VDD _0237_ sky130_fd_sc_hd__nand2_1
X_0818_ _0236_ _0237_ _0128_ VSS VSS VDD VDD _0238_ sky130_fd_sc_hd__nand3_1
X_0819_ _0096_ output_fcs[15] VSS VSS VDD VDD _0239_ sky130_fd_sc_hd__nand2_1
X_0820_ _0238_ _0239_ _0094_ VSS VSS VDD VDD _0017_ sky130_fd_sc_hd__a21oi_1
X_0821_ s_axis_tdata[4] crc_state[4] VSS VSS VDD VDD _0240_
+ sky130_fd_sc_hd__xnor2_2
X_0822_ _0240_ crc_0__eth_crc_inst_state_bits_16__with_shifted_state_network_tail
+ VSS VSS VDD VDD _0241_ sky130_fd_sc_hd__nand2_1
X_0823_ crc_0__eth_crc_inst_state_bits_16__with_shifted_state_network_tail
+ VSS VSS VDD VDD _0242_ sky130_fd_sc_hd__inv_1
X_0824_ _0168_ _0242_ VSS VSS VDD VDD _0243_ sky130_fd_sc_hd__nand2_1
X_0825_ _0241_ _0243_ VSS VSS VDD VDD _0244_ sky130_fd_sc_hd__nand2_1
X_0826_ _0244_ _0172_ VSS VSS VDD VDD _0245_ sky130_fd_sc_hd__nand2_1
X_0827_ _0241_ _0243_ _0109_ VSS VSS VDD VDD _0246_ sky130_fd_sc_hd__nand3_1
X_0828_ _0245_ _0246_ VSS VSS VDD VDD _0247_ sky130_fd_sc_hd__nand2_1
X_0829_ _0247_ _0155_ VSS VSS VDD VDD _0248_ sky130_fd_sc_hd__nand2_1
X_0830_ _0158_ _0245_ _0246_ VSS VSS VDD VDD _0249_ sky130_fd_sc_hd__nand3_1
X_0831_ _0248_ _0249_ _0128_ VSS VSS VDD VDD _0250_ sky130_fd_sc_hd__nand3_1
X_0832_ _0096_ output_fcs[16] VSS VSS VDD VDD _0251_ sky130_fd_sc_hd__nand2_1
X_0833_ _0250_ _0251_ _0094_ VSS VSS VDD VDD _0018_ sky130_fd_sc_hd__a21oi_1
X_0834_ _0173_ _0174_ _0104_ VSS VSS VDD VDD _0252_ sky130_fd_sc_hd__a21oi_1
X_0835_ _0173_ _0104_ _0174_ VSS VSS VDD VDD _0253_ sky130_fd_sc_hd__and3_1
X_0836_ crc_0__eth_crc_inst_state_bits_17__with_shifted_state_network_tail
+ VSS VSS VDD VDD _0254_ sky130_fd_sc_hd__inv_1
X_0837_ _0138_ _0254_ VSS VSS VDD VDD _0255_ sky130_fd_sc_hd__nand2_1
X_0838_ _0136_ _0137_ crc_0__eth_crc_inst_state_bits_17__with_shifted_state_network_tail
+ VSS VSS VDD VDD _0256_ sky130_fd_sc_hd__nand3_1
X_0839_ _0255_ _0256_ _0168_ VSS VSS VDD VDD _0257_ sky130_fd_sc_hd__a21oi_1
X_0840_ _0255_ _0124_ _0256_ VSS VSS VDD VDD _0258_ sky130_fd_sc_hd__and3_1
X_0841_ _0257_ _0258_ VSS VSS VDD VDD _0259_ sky130_fd_sc_hd__nor2_1
X_0842_ _0252_ _0253_ _0259_ VSS VSS VDD VDD _0260_ sky130_fd_sc_hd__o21ai_1
X_0843_ _0173_ _0174_ _0104_ VSS VSS VDD VDD _0261_ sky130_fd_sc_hd__nand3_1
X_0844_ _0175_ _0116_ VSS VSS VDD VDD _0262_ sky130_fd_sc_hd__nand2_1
X_0845_ _0257_ _0258_ _0261_ _0262_ VSS VSS VDD VDD _0263_
+ sky130_fd_sc_hd__o211ai_1
X_0846_ _0260_ _0263_ _0128_ VSS VSS VDD VDD _0264_ sky130_fd_sc_hd__nand3_1
X_0847_ _0096_ output_fcs[17] VSS VSS VDD VDD _0265_ sky130_fd_sc_hd__nand2_1
X_0848_ _0264_ _0265_ _0094_ VSS VSS VDD VDD _0019_ sky130_fd_sc_hd__a21oi_1
X_0849_ _0131_ _0132_ _0104_ VSS VSS VDD VDD _0266_ sky130_fd_sc_hd__a21oi_2
X_0850_ s_axis_tdata[0] VSS VSS VDD VDD _0267_ sky130_fd_sc_hd__inv_1
X_0851_ crc_state[0] _0267_ VSS VSS VDD VDD _0268_ sky130_fd_sc_hd__nor2_1
X_0852_ crc_state[0] VSS VSS VDD VDD _0269_ sky130_fd_sc_hd__inv_1
X_0853_ s_axis_tdata[0] _0269_ VSS VSS VDD VDD _0270_ sky130_fd_sc_hd__nor2_1
X_0854_ _0268_ _0270_ _0132_ _0131_ VSS VSS VDD VDD _0271_
+ sky130_fd_sc_hd__o211a_2
X_0855_ _0266_ _0271_ VSS VSS VDD VDD _0272_ sky130_fd_sc_hd__nor2_1
X_0856_ _0138_ _0240_ VSS VSS VDD VDD _0273_ sky130_fd_sc_hd__nor2_1
X_0857_ _0136_ _0137_ _0168_ VSS VSS VDD VDD _0274_ sky130_fd_sc_hd__a21oi_1
X_0858_ _0148_ _0149_ crc_0__eth_crc_inst_state_bits_18__with_shifted_state_network_tail
+ VSS VSS VDD VDD _0275_ sky130_fd_sc_hd__a21oi_1
X_0859_ _0148_ _0149_ crc_0__eth_crc_inst_state_bits_18__with_shifted_state_network_tail
+ VSS VSS VDD VDD _0276_ sky130_fd_sc_hd__and3_1
X_0860_ _0275_ _0276_ VSS VSS VDD VDD _0277_ sky130_fd_sc_hd__nor2_1
X_0861_ _0273_ _0274_ _0277_ VSS VSS VDD VDD _0278_ sky130_fd_sc_hd__o21ai_0
X_0862_ _0240_ _0181_ VSS VSS VDD VDD _0279_ sky130_fd_sc_hd__nand2_1
X_0863_ _0190_ _0168_ VSS VSS VDD VDD _0280_ sky130_fd_sc_hd__nand2_1
X_0864_ _0275_ _0276_ _0279_ _0280_ VSS VSS VDD VDD _0281_
+ sky130_fd_sc_hd__o211ai_1
X_0865_ _0278_ _0281_ VSS VSS VDD VDD _0282_ sky130_fd_sc_hd__nand2_1
X_0866_ _0272_ _0282_ VSS VSS VDD VDD _0283_ sky130_fd_sc_hd__nand2_1
X_0867_ _0266_ _0271_ _0278_ _0281_ VSS VSS VDD VDD _0284_
+ sky130_fd_sc_hd__o211ai_1
X_0868_ _0283_ _0284_ _0128_ VSS VSS VDD VDD _0285_ sky130_fd_sc_hd__nand3_1
X_0869_ _0096_ output_fcs[18] VSS VSS VDD VDD _0286_ sky130_fd_sc_hd__nand2_1
X_0870_ _0067_ VSS VSS VDD VDD _0287_ sky130_fd_sc_hd__clkbuf_1
X_0871_ _0285_ _0286_ _0287_ VSS VSS VDD VDD _0020_ sky130_fd_sc_hd__a21oi_1
X_0872_ _0231_ _0232_ _0072_ VSS VSS VDD VDD _0288_ sky130_fd_sc_hd__a21oi_1
X_0873_ _0071_ VSS VSS VDD VDD _0289_ sky130_fd_sc_hd__inv_1
X_0874_ _0070_ VSS VSS VDD VDD _0290_ sky130_fd_sc_hd__inv_1
X_0875_ _0289_ _0290_ _0232_ _0231_ VSS VSS VDD VDD _0291_
+ sky130_fd_sc_hd__o211a_1
X_0876_ _0288_ _0291_ VSS VSS VDD VDD _0292_ sky130_fd_sc_hd__nor2_1
X_0877_ _0074_ _0076_ crc_0__eth_crc_inst_state_bits_19__with_shifted_state_network_tail
+ VSS VSS VDD VDD _0293_ sky130_fd_sc_hd__a21oi_1
X_0878_ crc_0__eth_crc_inst_state_bits_19__with_shifted_state_network_tail
+ VSS VSS VDD VDD _0294_ sky130_fd_sc_hd__inv_1
X_0879_ _0294_ _0162_ _0163_ VSS VSS VDD VDD _0295_ sky130_fd_sc_hd__nor3_1
X_0880_ _0293_ _0295_ VSS VSS VDD VDD _0296_ sky130_fd_sc_hd__nor2_1
X_0881_ _0187_ _0137_ _0136_ VSS VSS VDD VDD _0297_ sky130_fd_sc_hd__nand3_2
X_0882_ _0138_ _0149_ _0148_ VSS VSS VDD VDD _0298_ sky130_fd_sc_hd__nand3_1
X_0883_ _0297_ _0298_ VSS VSS VDD VDD _0299_ sky130_fd_sc_hd__nand2_1
X_0884_ _0296_ _0299_ VSS VSS VDD VDD _0300_ sky130_fd_sc_hd__nand2_1
X_0885_ _0293_ _0295_ _0298_ _0297_ VSS VSS VDD VDD _0301_
+ sky130_fd_sc_hd__o211ai_1
X_0886_ _0300_ _0301_ VSS VSS VDD VDD _0302_ sky130_fd_sc_hd__nand2_1
X_0887_ _0292_ _0302_ VSS VSS VDD VDD _0303_ sky130_fd_sc_hd__nand2_1
X_0888_ _0288_ _0291_ _0300_ _0301_ VSS VSS VDD VDD _0304_
+ sky130_fd_sc_hd__o211ai_1
X_0889_ _0303_ _0304_ _0128_ VSS VSS VDD VDD _0305_ sky130_fd_sc_hd__nand3_1
X_0890_ _0096_ output_fcs[19] VSS VSS VDD VDD _0306_ sky130_fd_sc_hd__nand2_1
X_0891_ _0305_ _0306_ _0287_ VSS VSS VDD VDD _0021_ sky130_fd_sc_hd__a21oi_1
X_0892_ _0164_ crc_0__eth_crc_inst_state_bits_20__with_shifted_state_network_tail
+ VSS VSS VDD VDD _0307_ sky130_fd_sc_hd__nand2_1
X_0893_ crc_0__eth_crc_inst_state_bits_20__with_shifted_state_network_tail
+ VSS VSS VDD VDD _0308_ sky130_fd_sc_hd__inv_1
X_0894_ _0077_ _0308_ VSS VSS VDD VDD _0309_ sky130_fd_sc_hd__nand2_1
X_0895_ _0307_ _0309_ _0187_ VSS VSS VDD VDD _0310_ sky130_fd_sc_hd__a21oi_1
X_0896_ _0307_ _0187_ _0309_ VSS VSS VDD VDD _0311_ sky130_fd_sc_hd__and3_1
X_0897_ _0124_ _0108_ _0107_ VSS VSS VDD VDD _0312_ sky130_fd_sc_hd__nand3_1
X_0898_ _0240_ _0109_ VSS VSS VDD VDD _0313_ sky130_fd_sc_hd__nand2_1
X_0899_ _0312_ _0313_ VSS VSS VDD VDD _0314_ sky130_fd_sc_hd__and2_1
X_0900_ _0310_ _0311_ _0314_ VSS VSS VDD VDD _0315_ sky130_fd_sc_hd__o21ai_1
X_0901_ _0307_ _0309_ _0187_ VSS VSS VDD VDD _0316_ sky130_fd_sc_hd__nand3_1
X_0902_ _0312_ _0313_ VSS VSS VDD VDD _0317_ sky130_fd_sc_hd__nand2_1
X_0903_ _0310_ _0316_ _0317_ VSS VSS VDD VDD _0318_ sky130_fd_sc_hd__nand3b_1
X_0904_ _0315_ _0318_ _0128_ VSS VSS VDD VDD _0319_ sky130_fd_sc_hd__nand3_1
X_0905_ _0096_ output_fcs[20] VSS VSS VDD VDD _0320_ sky130_fd_sc_hd__nand2_1
X_0906_ _0319_ _0320_ _0287_ VSS VSS VDD VDD _0022_ sky130_fd_sc_hd__a21oi_1
X_0907_ _0164_ crc_0__eth_crc_inst_state_bits_21__with_shifted_state_network_tail
+ VSS VSS VDD VDD _0321_ sky130_fd_sc_hd__nand2_1
X_0908_ crc_0__eth_crc_inst_state_bits_21__with_shifted_state_network_tail
+ VSS VSS VDD VDD _0322_ sky130_fd_sc_hd__inv_1
X_0909_ _0077_ _0322_ VSS VSS VDD VDD _0323_ sky130_fd_sc_hd__nand2_1
X_0910_ _0321_ _0323_ _0181_ VSS VSS VDD VDD _0324_ sky130_fd_sc_hd__a21oi_1
X_0911_ _0321_ _0181_ _0323_ VSS VSS VDD VDD _0325_ sky130_fd_sc_hd__and3_1
X_0912_ _0100_ _0240_ VSS VSS VDD VDD _0326_ sky130_fd_sc_hd__xnor2_1
X_0913_ _0324_ _0325_ _0326_ VSS VSS VDD VDD _0327_ sky130_fd_sc_hd__o21bai_1
X_0914_ _0321_ _0323_ _0181_ VSS VSS VDD VDD _0328_ sky130_fd_sc_hd__nand3_1
X_0915_ _0324_ _0328_ _0326_ VSS VSS VDD VDD _0329_ sky130_fd_sc_hd__nand3b_1
X_0916_ _0327_ _0329_ _0128_ VSS VSS VDD VDD _0330_ sky130_fd_sc_hd__nand3_1
X_0917_ _0096_ output_fcs[21] VSS VSS VDD VDD _0331_ sky130_fd_sc_hd__nand2_1
X_0918_ _0330_ _0331_ _0287_ VSS VSS VDD VDD _0023_ sky130_fd_sc_hd__a21oi_1
X_0919_ _0146_ crc_0__eth_crc_inst_state_bits_22__with_shifted_state_network_tail
+ VSS VSS VDD VDD _0332_ sky130_fd_sc_hd__nand2_1
X_0920_ crc_0__eth_crc_inst_state_bits_22__with_shifted_state_network_tail
+ VSS VSS VDD VDD _0333_ sky130_fd_sc_hd__inv_1
X_0921_ _0150_ _0333_ VSS VSS VDD VDD _0334_ sky130_fd_sc_hd__nand2_1
X_0922_ _0332_ _0334_ _0181_ VSS VSS VDD VDD _0335_ sky130_fd_sc_hd__a21oi_1
X_0923_ _0332_ _0181_ _0334_ VSS VSS VDD VDD _0336_ sky130_fd_sc_hd__and3_1
X_0924_ _0335_ _0336_ _0233_ VSS VSS VDD VDD _0337_ sky130_fd_sc_hd__o21bai_1
X_0925_ _0332_ _0334_ _0181_ VSS VSS VDD VDD _0338_ sky130_fd_sc_hd__nand3_1
X_0926_ _0335_ _0338_ _0233_ VSS VSS VDD VDD _0339_ sky130_fd_sc_hd__nand3b_1
X_0927_ _0337_ _0339_ _0088_ VSS VSS VDD VDD _0340_ sky130_fd_sc_hd__nand3_1
X_0928_ _0204_ output_fcs[22] VSS VSS VDD VDD _0341_ sky130_fd_sc_hd__nand2_1
X_0929_ _0340_ _0341_ _0287_ VSS VSS VDD VDD _0024_ sky130_fd_sc_hd__a21oi_1
X_0930_ _0164_ crc_0__eth_crc_inst_state_bits_23__with_shifted_state_network_tail
+ VSS VSS VDD VDD _0342_ sky130_fd_sc_hd__nand2_1
X_0931_ _0077_ _0065_ VSS VSS VDD VDD _0343_ sky130_fd_sc_hd__nand2_1
X_0932_ _0342_ _0343_ _0187_ VSS VSS VDD VDD _0344_ sky130_fd_sc_hd__a21oi_1
X_0933_ _0342_ _0187_ _0343_ VSS VSS VDD VDD _0345_ sky130_fd_sc_hd__and3_1
X_0934_ _0344_ _0345_ _0314_ VSS VSS VDD VDD _0346_ sky130_fd_sc_hd__o21ai_1
X_0935_ _0342_ _0343_ _0187_ VSS VSS VDD VDD _0347_ sky130_fd_sc_hd__nand3_1
X_0936_ _0344_ _0347_ _0317_ VSS VSS VDD VDD _0348_ sky130_fd_sc_hd__nand3b_1
X_0937_ _0346_ _0348_ _0088_ VSS VSS VDD VDD _0349_ sky130_fd_sc_hd__nand3_1
X_0938_ _0204_ output_fcs[23] VSS VSS VDD VDD _0350_ sky130_fd_sc_hd__nand2_1
X_0939_ _0349_ _0350_ _0287_ VSS VSS VDD VDD _0025_ sky130_fd_sc_hd__a21oi_1
X_0940_ _0190_ _0077_ VSS VSS VDD VDD _0351_ sky130_fd_sc_hd__nand2_1
X_0941_ _0164_ _0138_ VSS VSS VDD VDD _0352_ sky130_fd_sc_hd__nand2_1
X_0942_ _0351_ _0352_ _0168_ VSS VSS VDD VDD _0353_ sky130_fd_sc_hd__a21oi_1
X_0943_ _0351_ _0352_ _0124_ VSS VSS VDD VDD _0354_ sky130_fd_sc_hd__and3_1
X_0944_ _0353_ _0354_ _0155_ VSS VSS VDD VDD _0355_ sky130_fd_sc_hd__o21ai_1
X_0945_ _0351_ _0352_ VSS VSS VDD VDD _0356_ sky130_fd_sc_hd__nand2_1
X_0946_ _0356_ _0240_ VSS VSS VDD VDD _0357_ sky130_fd_sc_hd__nand2_1
X_0947_ _0351_ _0352_ _0168_ VSS VSS VDD VDD _0358_ sky130_fd_sc_hd__nand3_1
X_0948_ _0357_ _0358_ _0158_ VSS VSS VDD VDD _0359_ sky130_fd_sc_hd__nand3_1
X_0949_ _0355_ _0359_ _0088_ VSS VSS VDD VDD _0360_ sky130_fd_sc_hd__nand3_1
X_0950_ _0204_ output_fcs[24] VSS VSS VDD VDD _0361_ sky130_fd_sc_hd__nand2_1
X_0951_ _0360_ _0361_ _0287_ VSS VSS VDD VDD _0026_ sky130_fd_sc_hd__a21oi_1
X_0952_ _0299_ _0172_ VSS VSS VDD VDD _0362_ sky130_fd_sc_hd__nand2_1
X_0953_ _0298_ _0297_ _0109_ VSS VSS VDD VDD _0363_ sky130_fd_sc_hd__nand3_1
X_0954_ _0362_ _0363_ VSS VSS VDD VDD _0364_ sky130_fd_sc_hd__nand2_1
X_0955_ _0272_ _0364_ VSS VSS VDD VDD _0365_ sky130_fd_sc_hd__nand2_1
X_0956_ _0266_ _0271_ _0363_ _0362_ VSS VSS VDD VDD _0366_
+ sky130_fd_sc_hd__o211ai_1
X_0957_ _0365_ _0366_ _0088_ VSS VSS VDD VDD _0367_ sky130_fd_sc_hd__nand3_1
X_0958_ clknet_3_1__leaf_clk _0064_ VSS VSS VDD VDD output_fcs_valid
+ sky130_fd_sc_hd__dfxtp_1
X_0959_ clknet_3_4__leaf_clk _0002_ VSS VSS VDD VDD output_fcs[0]
+ sky130_fd_sc_hd__dfxtp_1
X_0960_ clknet_3_5__leaf_clk _0003_ VSS VSS VDD VDD output_fcs[1]
+ sky130_fd_sc_hd__dfxtp_1
X_0961_ clknet_3_4__leaf_clk _0004_ VSS VSS VDD VDD output_fcs[2]
+ sky130_fd_sc_hd__dfxtp_1
X_0962_ clknet_3_4__leaf_clk _0005_ VSS VSS VDD VDD output_fcs[3]
+ sky130_fd_sc_hd__dfxtp_1
X_0963_ clknet_3_4__leaf_clk _0006_ VSS VSS VDD VDD output_fcs[4]
+ sky130_fd_sc_hd__dfxtp_1
X_0964_ clknet_3_0__leaf_clk _0007_ VSS VSS VDD VDD output_fcs[5]
+ sky130_fd_sc_hd__dfxtp_1
X_0965_ clknet_3_0__leaf_clk _0008_ VSS VSS VDD VDD output_fcs[6]
+ sky130_fd_sc_hd__dfxtp_1
X_0966_ clknet_3_4__leaf_clk _0009_ VSS VSS VDD VDD output_fcs[7]
+ sky130_fd_sc_hd__dfxtp_1
X_0967_ clknet_3_0__leaf_clk _0010_ VSS VSS VDD VDD output_fcs[8]
+ sky130_fd_sc_hd__dfxtp_1
X_0968_ clknet_3_1__leaf_clk _0011_ VSS VSS VDD VDD output_fcs[9]
+ sky130_fd_sc_hd__dfxtp_1
X_0969_ clknet_3_5__leaf_clk _0012_ VSS VSS VDD VDD output_fcs[10]
+ sky130_fd_sc_hd__dfxtp_1
X_0970_ clknet_3_4__leaf_clk _0013_ VSS VSS VDD VDD output_fcs[11]
+ sky130_fd_sc_hd__dfxtp_1
X_0971_ clknet_3_5__leaf_clk _0014_ VSS VSS VDD VDD output_fcs[12]
+ sky130_fd_sc_hd__dfxtp_1
X_0972_ clknet_3_1__leaf_clk _0015_ VSS VSS VDD VDD output_fcs[13]
+ sky130_fd_sc_hd__dfxtp_1
X_0973_ clknet_3_1__leaf_clk _0016_ VSS VSS VDD VDD output_fcs[14]
+ sky130_fd_sc_hd__dfxtp_1
X_0974_ clknet_3_5__leaf_clk _0017_ VSS VSS VDD VDD output_fcs[15]
+ sky130_fd_sc_hd__dfxtp_1
X_0975_ clknet_3_5__leaf_clk _0018_ VSS VSS VDD VDD output_fcs[16]
+ sky130_fd_sc_hd__dfxtp_1
X_0976_ clknet_3_3__leaf_clk _0019_ VSS VSS VDD VDD output_fcs[17]
+ sky130_fd_sc_hd__dfxtp_1
X_0977_ clknet_3_1__leaf_clk _0020_ VSS VSS VDD VDD output_fcs[18]
+ sky130_fd_sc_hd__dfxtp_1
X_0978_ clknet_3_1__leaf_clk _0021_ VSS VSS VDD VDD output_fcs[19]
+ sky130_fd_sc_hd__dfxtp_1
X_0979_ clknet_3_5__leaf_clk _0022_ VSS VSS VDD VDD output_fcs[20]
+ sky130_fd_sc_hd__dfxtp_1
X_0980_ clknet_3_1__leaf_clk _0023_ VSS VSS VDD VDD output_fcs[21]
+ sky130_fd_sc_hd__dfxtp_1
X_0981_ clknet_3_5__leaf_clk _0024_ VSS VSS VDD VDD output_fcs[22]
+ sky130_fd_sc_hd__dfxtp_1
X_0982_ clknet_3_5__leaf_clk _0025_ VSS VSS VDD VDD output_fcs[23]
+ sky130_fd_sc_hd__dfxtp_1
X_0983_ clknet_3_4__leaf_clk _0026_ VSS VSS VDD VDD output_fcs[24]
+ sky130_fd_sc_hd__dfxtp_1
X_0984_ clknet_3_0__leaf_clk _0027_ VSS VSS VDD VDD output_fcs[25]
+ sky130_fd_sc_hd__dfxtp_1
X_0985_ clknet_3_0__leaf_clk _0028_ VSS VSS VDD VDD output_fcs[26]
+ sky130_fd_sc_hd__dfxtp_1
X_0986_ clknet_3_0__leaf_clk _0029_ VSS VSS VDD VDD output_fcs[27]
+ sky130_fd_sc_hd__dfxtp_1
X_0987_ clknet_3_1__leaf_clk _0030_ VSS VSS VDD VDD output_fcs[28]
+ sky130_fd_sc_hd__dfxtp_1
X_0988_ clknet_3_1__leaf_clk _0031_ VSS VSS VDD VDD output_fcs[29]
+ sky130_fd_sc_hd__dfxtp_1
X_0989_ clknet_3_4__leaf_clk _0032_ VSS VSS VDD VDD output_fcs[30]
+ sky130_fd_sc_hd__dfxtp_1
X_0990_ clknet_3_5__leaf_clk _0001_ VSS VSS VDD VDD output_fcs[31]
+ sky130_fd_sc_hd__dfxtp_1
X_0991_ clknet_3_6__leaf_clk _0033_ VSS VSS VDD VDD crc_state[0]
+ sky130_fd_sc_hd__dfxtp_1
X_0992_ clknet_3_3__leaf_clk _0034_ VSS VSS VDD VDD crc_state[1]
+ sky130_fd_sc_hd__dfxtp_1
X_0993_ clknet_3_3__leaf_clk _0035_ VSS VSS VDD VDD crc_state[2]
+ sky130_fd_sc_hd__dfxtp_1
X_0994_ clknet_3_3__leaf_clk _0036_ VSS VSS VDD VDD crc_state[3]
+ sky130_fd_sc_hd__dfxtp_1
X_0995_ clknet_3_5__leaf_clk _0037_ VSS VSS VDD VDD crc_state[4]
+ sky130_fd_sc_hd__dfxtp_1
X_0996_ clknet_3_2__leaf_clk _0038_ VSS VSS VDD VDD crc_state[5]
+ sky130_fd_sc_hd__dfxtp_1
X_0997_ clknet_3_2__leaf_clk _0039_ VSS VSS VDD VDD crc_state[6]
+ sky130_fd_sc_hd__dfxtp_1
X_0998_ clknet_3_3__leaf_clk _0040_ VSS VSS VDD VDD crc_state[7]
+ sky130_fd_sc_hd__dfxtp_1
X_0999_ clknet_3_0__leaf_clk _0041_ VSS VSS VDD VDD crc_0__eth_crc_inst_state_bits_0__with_shifted_state_network_tail
+ sky130_fd_sc_hd__dfxtp_1
X_1000_ clknet_3_5__leaf_clk _0042_ VSS VSS VDD VDD crc_0__eth_crc_inst_state_bits_1__with_shifted_state_network_tail
+ sky130_fd_sc_hd__dfxtp_1
X_1001_ clknet_3_5__leaf_clk _0043_ VSS VSS VDD VDD crc_0__eth_crc_inst_state_bits_2__with_shifted_state_network_tail
+ sky130_fd_sc_hd__dfxtp_1
X_1002_ clknet_3_6__leaf_clk _0044_ VSS VSS VDD VDD crc_0__eth_crc_inst_state_bits_3__with_shifted_state_network_tail
+ sky130_fd_sc_hd__dfxtp_1
X_1003_ clknet_3_7__leaf_clk _0045_ VSS VSS VDD VDD crc_0__eth_crc_inst_state_bits_4__with_shifted_state_network_tail
+ sky130_fd_sc_hd__dfxtp_1
X_1004_ clknet_3_2__leaf_clk _0046_ VSS VSS VDD VDD crc_0__eth_crc_inst_state_bits_5__with_shifted_state_network_tail
+ sky130_fd_sc_hd__dfxtp_1
X_1005_ clknet_3_2__leaf_clk _0047_ VSS VSS VDD VDD crc_0__eth_crc_inst_state_bits_6__with_shifted_state_network_tail
+ sky130_fd_sc_hd__dfxtp_1
X_1006_ clknet_3_7__leaf_clk _0048_ VSS VSS VDD VDD crc_0__eth_crc_inst_state_bits_7__with_shifted_state_network_tail
+ sky130_fd_sc_hd__dfxtp_1
X_1007_ clknet_3_0__leaf_clk _0049_ VSS VSS VDD VDD crc_0__eth_crc_inst_state_bits_8__with_shifted_state_network_tail
+ sky130_fd_sc_hd__dfxtp_1
X_1008_ clknet_3_0__leaf_clk _0050_ VSS VSS VDD VDD crc_0__eth_crc_inst_state_bits_9__with_shifted_state_network_tail
+ sky130_fd_sc_hd__dfxtp_1
X_1009_ clknet_3_6__leaf_clk _0051_ VSS VSS VDD VDD crc_0__eth_crc_inst_state_bits_10__with_shifted_state_network_tail
+ sky130_fd_sc_hd__dfxtp_1
X_1010_ clknet_3_7__leaf_clk _0052_ VSS VSS VDD VDD crc_0__eth_crc_inst_state_bits_11__with_shifted_state_network_tail
+ sky130_fd_sc_hd__dfxtp_1
X_1011_ clknet_3_7__leaf_clk _0053_ VSS VSS VDD VDD crc_0__eth_crc_inst_state_bits_12__with_shifted_state_network_tail
+ sky130_fd_sc_hd__dfxtp_1
X_1012_ clknet_3_6__leaf_clk _0054_ VSS VSS VDD VDD crc_0__eth_crc_inst_state_bits_13__with_shifted_state_network_tail
+ sky130_fd_sc_hd__dfxtp_1
X_1013_ clknet_3_7__leaf_clk _0055_ VSS VSS VDD VDD crc_0__eth_crc_inst_state_bits_14__with_shifted_state_network_tail
+ sky130_fd_sc_hd__dfxtp_1
X_1014_ clknet_3_7__leaf_clk _0056_ VSS VSS VDD VDD crc_0__eth_crc_inst_state_bits_15__with_shifted_state_network_tail
+ sky130_fd_sc_hd__dfxtp_1
X_1015_ clknet_3_0__leaf_clk _0057_ VSS VSS VDD VDD crc_0__eth_crc_inst_state_bits_16__with_shifted_state_network_tail
+ sky130_fd_sc_hd__dfxtp_1
X_1016_ clknet_3_2__leaf_clk _0058_ VSS VSS VDD VDD crc_0__eth_crc_inst_state_bits_17__with_shifted_state_network_tail
+ sky130_fd_sc_hd__dfxtp_1
X_1017_ clknet_3_2__leaf_clk _0059_ VSS VSS VDD VDD crc_0__eth_crc_inst_state_bits_18__with_shifted_state_network_tail
+ sky130_fd_sc_hd__dfxtp_1
X_1018_ clknet_3_2__leaf_clk _0060_ VSS VSS VDD VDD crc_0__eth_crc_inst_state_bits_19__with_shifted_state_network_tail
+ sky130_fd_sc_hd__dfxtp_1
X_1019_ clknet_3_7__leaf_clk _0061_ VSS VSS VDD VDD crc_0__eth_crc_inst_state_bits_20__with_shifted_state_network_tail
+ sky130_fd_sc_hd__dfxtp_1
X_1020_ clknet_3_6__leaf_clk _0062_ VSS VSS VDD VDD crc_0__eth_crc_inst_state_bits_21__with_shifted_state_network_tail
+ sky130_fd_sc_hd__dfxtp_1
X_1021_ clknet_3_6__leaf_clk _0063_ VSS VSS VDD VDD crc_0__eth_crc_inst_state_bits_22__with_shifted_state_network_tail
+ sky130_fd_sc_hd__dfxtp_1
X_1022_ clknet_3_7__leaf_clk _0000_ VSS VSS VDD VDD crc_0__eth_crc_inst_state_bits_23__with_shifted_state_network_tail
+ sky130_fd_sc_hd__dfxtp_1
X_1023_ VSS VSS VDD VDD s_axis_tready _unconnected_0 sky130_fd_sc_hd__conb_1
XTAP_TAPCELL_ROW_0_0 VSS VDD sky130_fd_sc_hd__tapvpwrvgnd_1
XTAP_TAPCELL_ROW_0_1 VSS VDD sky130_fd_sc_hd__tapvpwrvgnd_1
XTAP_TAPCELL_ROW_0_2 VSS VDD sky130_fd_sc_hd__tapvpwrvgnd_1
XTAP_TAPCELL_ROW_0_3 VSS VDD sky130_fd_sc_hd__tapvpwrvgnd_1
XTAP_TAPCELL_ROW_0_4 VSS VDD sky130_fd_sc_hd__tapvpwrvgnd_1
XTAP_TAPCELL_ROW_0_5 VSS VDD sky130_fd_sc_hd__tapvpwrvgnd_1
XTAP_TAPCELL_ROW_0_6 VSS VDD sky130_fd_sc_hd__tapvpwrvgnd_1
XTAP_TAPCELL_ROW_1_7 VSS VDD sky130_fd_sc_hd__tapvpwrvgnd_1
XTAP_TAPCELL_ROW_1_8 VSS VDD sky130_fd_sc_hd__tapvpwrvgnd_1
XTAP_TAPCELL_ROW_1_9 VSS VDD sky130_fd_sc_hd__tapvpwrvgnd_1
XTAP_TAPCELL_ROW_2_10 VSS VDD sky130_fd_sc_hd__tapvpwrvgnd_1
XTAP_TAPCELL_ROW_2_11 VSS VDD sky130_fd_sc_hd__tapvpwrvgnd_1
XTAP_TAPCELL_ROW_2_12 VSS VDD sky130_fd_sc_hd__tapvpwrvgnd_1
XTAP_TAPCELL_ROW_2_13 VSS VDD sky130_fd_sc_hd__tapvpwrvgnd_1
XTAP_TAPCELL_ROW_3_14 VSS VDD sky130_fd_sc_hd__tapvpwrvgnd_1
XTAP_TAPCELL_ROW_3_15 VSS VDD sky130_fd_sc_hd__tapvpwrvgnd_1
XTAP_TAPCELL_ROW_3_16 VSS VDD sky130_fd_sc_hd__tapvpwrvgnd_1
XTAP_TAPCELL_ROW_4_17 VSS VDD sky130_fd_sc_hd__tapvpwrvgnd_1
XTAP_TAPCELL_ROW_4_18 VSS VDD sky130_fd_sc_hd__tapvpwrvgnd_1
XTAP_TAPCELL_ROW_4_19 VSS VDD sky130_fd_sc_hd__tapvpwrvgnd_1
XTAP_TAPCELL_ROW_4_20 VSS VDD sky130_fd_sc_hd__tapvpwrvgnd_1
XTAP_TAPCELL_ROW_5_21 VSS VDD sky130_fd_sc_hd__tapvpwrvgnd_1
XTAP_TAPCELL_ROW_5_22 VSS VDD sky130_fd_sc_hd__tapvpwrvgnd_1
XTAP_TAPCELL_ROW_5_23 VSS VDD sky130_fd_sc_hd__tapvpwrvgnd_1
XTAP_TAPCELL_ROW_6_24 VSS VDD sky130_fd_sc_hd__tapvpwrvgnd_1
XTAP_TAPCELL_ROW_6_25 VSS VDD sky130_fd_sc_hd__tapvpwrvgnd_1
XTAP_TAPCELL_ROW_6_26 VSS VDD sky130_fd_sc_hd__tapvpwrvgnd_1
XTAP_TAPCELL_ROW_6_27 VSS VDD sky130_fd_sc_hd__tapvpwrvgnd_1
XTAP_TAPCELL_ROW_7_28 VSS VDD sky130_fd_sc_hd__tapvpwrvgnd_1
XTAP_TAPCELL_ROW_7_29 VSS VDD sky130_fd_sc_hd__tapvpwrvgnd_1
XTAP_TAPCELL_ROW_7_30 VSS VDD sky130_fd_sc_hd__tapvpwrvgnd_1
XTAP_TAPCELL_ROW_8_31 VSS VDD sky130_fd_sc_hd__tapvpwrvgnd_1
XTAP_TAPCELL_ROW_8_32 VSS VDD sky130_fd_sc_hd__tapvpwrvgnd_1
XTAP_TAPCELL_ROW_8_33 VSS VDD sky130_fd_sc_hd__tapvpwrvgnd_1
XTAP_TAPCELL_ROW_8_34 VSS VDD sky130_fd_sc_hd__tapvpwrvgnd_1
XTAP_TAPCELL_ROW_9_35 VSS VDD sky130_fd_sc_hd__tapvpwrvgnd_1
XTAP_TAPCELL_ROW_9_36 VSS VDD sky130_fd_sc_hd__tapvpwrvgnd_1
XTAP_TAPCELL_ROW_9_37 VSS VDD sky130_fd_sc_hd__tapvpwrvgnd_1
XTAP_TAPCELL_ROW_10_38 VSS VDD sky130_fd_sc_hd__tapvpwrvgnd_1
XTAP_TAPCELL_ROW_10_39 VSS VDD sky130_fd_sc_hd__tapvpwrvgnd_1
XTAP_TAPCELL_ROW_10_40 VSS VDD sky130_fd_sc_hd__tapvpwrvgnd_1
XTAP_TAPCELL_ROW_10_41 VSS VDD sky130_fd_sc_hd__tapvpwrvgnd_1
XTAP_TAPCELL_ROW_11_42 VSS VDD sky130_fd_sc_hd__tapvpwrvgnd_1
XTAP_TAPCELL_ROW_11_43 VSS VDD sky130_fd_sc_hd__tapvpwrvgnd_1
XTAP_TAPCELL_ROW_11_44 VSS VDD sky130_fd_sc_hd__tapvpwrvgnd_1
XTAP_TAPCELL_ROW_12_45 VSS VDD sky130_fd_sc_hd__tapvpwrvgnd_1
XTAP_TAPCELL_ROW_12_46 VSS VDD sky130_fd_sc_hd__tapvpwrvgnd_1
XTAP_TAPCELL_ROW_12_47 VSS VDD sky130_fd_sc_hd__tapvpwrvgnd_1
XTAP_TAPCELL_ROW_12_48 VSS VDD sky130_fd_sc_hd__tapvpwrvgnd_1
XTAP_TAPCELL_ROW_13_49 VSS VDD sky130_fd_sc_hd__tapvpwrvgnd_1
XTAP_TAPCELL_ROW_13_50 VSS VDD sky130_fd_sc_hd__tapvpwrvgnd_1
XTAP_TAPCELL_ROW_13_51 VSS VDD sky130_fd_sc_hd__tapvpwrvgnd_1
XTAP_TAPCELL_ROW_14_52 VSS VDD sky130_fd_sc_hd__tapvpwrvgnd_1
XTAP_TAPCELL_ROW_14_53 VSS VDD sky130_fd_sc_hd__tapvpwrvgnd_1
XTAP_TAPCELL_ROW_14_54 VSS VDD sky130_fd_sc_hd__tapvpwrvgnd_1
XTAP_TAPCELL_ROW_14_55 VSS VDD sky130_fd_sc_hd__tapvpwrvgnd_1
XTAP_TAPCELL_ROW_15_56 VSS VDD sky130_fd_sc_hd__tapvpwrvgnd_1
XTAP_TAPCELL_ROW_15_57 VSS VDD sky130_fd_sc_hd__tapvpwrvgnd_1
XTAP_TAPCELL_ROW_15_58 VSS VDD sky130_fd_sc_hd__tapvpwrvgnd_1
XTAP_TAPCELL_ROW_16_59 VSS VDD sky130_fd_sc_hd__tapvpwrvgnd_1
XTAP_TAPCELL_ROW_16_60 VSS VDD sky130_fd_sc_hd__tapvpwrvgnd_1
XTAP_TAPCELL_ROW_16_61 VSS VDD sky130_fd_sc_hd__tapvpwrvgnd_1
XTAP_TAPCELL_ROW_16_62 VSS VDD sky130_fd_sc_hd__tapvpwrvgnd_1
XTAP_TAPCELL_ROW_17_63 VSS VDD sky130_fd_sc_hd__tapvpwrvgnd_1
XTAP_TAPCELL_ROW_17_64 VSS VDD sky130_fd_sc_hd__tapvpwrvgnd_1
XTAP_TAPCELL_ROW_17_65 VSS VDD sky130_fd_sc_hd__tapvpwrvgnd_1
XTAP_TAPCELL_ROW_18_66 VSS VDD sky130_fd_sc_hd__tapvpwrvgnd_1
XTAP_TAPCELL_ROW_18_67 VSS VDD sky130_fd_sc_hd__tapvpwrvgnd_1
XTAP_TAPCELL_ROW_18_68 VSS VDD sky130_fd_sc_hd__tapvpwrvgnd_1
XTAP_TAPCELL_ROW_18_69 VSS VDD sky130_fd_sc_hd__tapvpwrvgnd_1
XTAP_TAPCELL_ROW_19_70 VSS VDD sky130_fd_sc_hd__tapvpwrvgnd_1
XTAP_TAPCELL_ROW_19_71 VSS VDD sky130_fd_sc_hd__tapvpwrvgnd_1
XTAP_TAPCELL_ROW_19_72 VSS VDD sky130_fd_sc_hd__tapvpwrvgnd_1
XTAP_TAPCELL_ROW_20_73 VSS VDD sky130_fd_sc_hd__tapvpwrvgnd_1
XTAP_TAPCELL_ROW_20_74 VSS VDD sky130_fd_sc_hd__tapvpwrvgnd_1
XTAP_TAPCELL_ROW_20_75 VSS VDD sky130_fd_sc_hd__tapvpwrvgnd_1
XTAP_TAPCELL_ROW_20_76 VSS VDD sky130_fd_sc_hd__tapvpwrvgnd_1
XTAP_TAPCELL_ROW_21_77 VSS VDD sky130_fd_sc_hd__tapvpwrvgnd_1
XTAP_TAPCELL_ROW_21_78 VSS VDD sky130_fd_sc_hd__tapvpwrvgnd_1
XTAP_TAPCELL_ROW_21_79 VSS VDD sky130_fd_sc_hd__tapvpwrvgnd_1
XTAP_TAPCELL_ROW_22_80 VSS VDD sky130_fd_sc_hd__tapvpwrvgnd_1
XTAP_TAPCELL_ROW_22_81 VSS VDD sky130_fd_sc_hd__tapvpwrvgnd_1
XTAP_TAPCELL_ROW_22_82 VSS VDD sky130_fd_sc_hd__tapvpwrvgnd_1
XTAP_TAPCELL_ROW_22_83 VSS VDD sky130_fd_sc_hd__tapvpwrvgnd_1
XTAP_TAPCELL_ROW_23_84 VSS VDD sky130_fd_sc_hd__tapvpwrvgnd_1
XTAP_TAPCELL_ROW_23_85 VSS VDD sky130_fd_sc_hd__tapvpwrvgnd_1
XTAP_TAPCELL_ROW_23_86 VSS VDD sky130_fd_sc_hd__tapvpwrvgnd_1
XTAP_TAPCELL_ROW_24_87 VSS VDD sky130_fd_sc_hd__tapvpwrvgnd_1
XTAP_TAPCELL_ROW_24_88 VSS VDD sky130_fd_sc_hd__tapvpwrvgnd_1
XTAP_TAPCELL_ROW_24_89 VSS VDD sky130_fd_sc_hd__tapvpwrvgnd_1
XTAP_TAPCELL_ROW_24_90 VSS VDD sky130_fd_sc_hd__tapvpwrvgnd_1
XTAP_TAPCELL_ROW_25_91 VSS VDD sky130_fd_sc_hd__tapvpwrvgnd_1
XTAP_TAPCELL_ROW_25_92 VSS VDD sky130_fd_sc_hd__tapvpwrvgnd_1
XTAP_TAPCELL_ROW_25_93 VSS VDD sky130_fd_sc_hd__tapvpwrvgnd_1
XTAP_TAPCELL_ROW_26_94 VSS VDD sky130_fd_sc_hd__tapvpwrvgnd_1
XTAP_TAPCELL_ROW_26_95 VSS VDD sky130_fd_sc_hd__tapvpwrvgnd_1
XTAP_TAPCELL_ROW_26_96 VSS VDD sky130_fd_sc_hd__tapvpwrvgnd_1
XTAP_TAPCELL_ROW_26_97 VSS VDD sky130_fd_sc_hd__tapvpwrvgnd_1
XTAP_TAPCELL_ROW_27_98 VSS VDD sky130_fd_sc_hd__tapvpwrvgnd_1
XTAP_TAPCELL_ROW_27_99 VSS VDD sky130_fd_sc_hd__tapvpwrvgnd_1
XTAP_TAPCELL_ROW_27_100 VSS VDD sky130_fd_sc_hd__tapvpwrvgnd_1
XTAP_TAPCELL_ROW_28_101 VSS VDD sky130_fd_sc_hd__tapvpwrvgnd_1
XTAP_TAPCELL_ROW_28_102 VSS VDD sky130_fd_sc_hd__tapvpwrvgnd_1
XTAP_TAPCELL_ROW_28_103 VSS VDD sky130_fd_sc_hd__tapvpwrvgnd_1
XTAP_TAPCELL_ROW_28_104 VSS VDD sky130_fd_sc_hd__tapvpwrvgnd_1
XTAP_TAPCELL_ROW_29_105 VSS VDD sky130_fd_sc_hd__tapvpwrvgnd_1
XTAP_TAPCELL_ROW_29_106 VSS VDD sky130_fd_sc_hd__tapvpwrvgnd_1
XTAP_TAPCELL_ROW_29_107 VSS VDD sky130_fd_sc_hd__tapvpwrvgnd_1
XTAP_TAPCELL_ROW_30_108 VSS VDD sky130_fd_sc_hd__tapvpwrvgnd_1
XTAP_TAPCELL_ROW_30_109 VSS VDD sky130_fd_sc_hd__tapvpwrvgnd_1
XTAP_TAPCELL_ROW_30_110 VSS VDD sky130_fd_sc_hd__tapvpwrvgnd_1
XTAP_TAPCELL_ROW_30_111 VSS VDD sky130_fd_sc_hd__tapvpwrvgnd_1
XTAP_TAPCELL_ROW_31_112 VSS VDD sky130_fd_sc_hd__tapvpwrvgnd_1
XTAP_TAPCELL_ROW_31_113 VSS VDD sky130_fd_sc_hd__tapvpwrvgnd_1
XTAP_TAPCELL_ROW_31_114 VSS VDD sky130_fd_sc_hd__tapvpwrvgnd_1
XTAP_TAPCELL_ROW_32_115 VSS VDD sky130_fd_sc_hd__tapvpwrvgnd_1
XTAP_TAPCELL_ROW_32_116 VSS VDD sky130_fd_sc_hd__tapvpwrvgnd_1
XTAP_TAPCELL_ROW_32_117 VSS VDD sky130_fd_sc_hd__tapvpwrvgnd_1
XTAP_TAPCELL_ROW_32_118 VSS VDD sky130_fd_sc_hd__tapvpwrvgnd_1
XTAP_TAPCELL_ROW_33_119 VSS VDD sky130_fd_sc_hd__tapvpwrvgnd_1
XTAP_TAPCELL_ROW_33_120 VSS VDD sky130_fd_sc_hd__tapvpwrvgnd_1
XTAP_TAPCELL_ROW_33_121 VSS VDD sky130_fd_sc_hd__tapvpwrvgnd_1
XTAP_TAPCELL_ROW_34_122 VSS VDD sky130_fd_sc_hd__tapvpwrvgnd_1
XTAP_TAPCELL_ROW_34_123 VSS VDD sky130_fd_sc_hd__tapvpwrvgnd_1
XTAP_TAPCELL_ROW_34_124 VSS VDD sky130_fd_sc_hd__tapvpwrvgnd_1
XTAP_TAPCELL_ROW_34_125 VSS VDD sky130_fd_sc_hd__tapvpwrvgnd_1
XTAP_TAPCELL_ROW_35_126 VSS VDD sky130_fd_sc_hd__tapvpwrvgnd_1
XTAP_TAPCELL_ROW_35_127 VSS VDD sky130_fd_sc_hd__tapvpwrvgnd_1
XTAP_TAPCELL_ROW_35_128 VSS VDD sky130_fd_sc_hd__tapvpwrvgnd_1
XTAP_TAPCELL_ROW_36_129 VSS VDD sky130_fd_sc_hd__tapvpwrvgnd_1
XTAP_TAPCELL_ROW_36_130 VSS VDD sky130_fd_sc_hd__tapvpwrvgnd_1
XTAP_TAPCELL_ROW_36_131 VSS VDD sky130_fd_sc_hd__tapvpwrvgnd_1
XTAP_TAPCELL_ROW_36_132 VSS VDD sky130_fd_sc_hd__tapvpwrvgnd_1
XTAP_TAPCELL_ROW_37_133 VSS VDD sky130_fd_sc_hd__tapvpwrvgnd_1
XTAP_TAPCELL_ROW_37_134 VSS VDD sky130_fd_sc_hd__tapvpwrvgnd_1
XTAP_TAPCELL_ROW_37_135 VSS VDD sky130_fd_sc_hd__tapvpwrvgnd_1
XTAP_TAPCELL_ROW_38_136 VSS VDD sky130_fd_sc_hd__tapvpwrvgnd_1
XTAP_TAPCELL_ROW_38_137 VSS VDD sky130_fd_sc_hd__tapvpwrvgnd_1
XTAP_TAPCELL_ROW_38_138 VSS VDD sky130_fd_sc_hd__tapvpwrvgnd_1
XTAP_TAPCELL_ROW_38_139 VSS VDD sky130_fd_sc_hd__tapvpwrvgnd_1
XTAP_TAPCELL_ROW_39_140 VSS VDD sky130_fd_sc_hd__tapvpwrvgnd_1
XTAP_TAPCELL_ROW_39_141 VSS VDD sky130_fd_sc_hd__tapvpwrvgnd_1
XTAP_TAPCELL_ROW_39_142 VSS VDD sky130_fd_sc_hd__tapvpwrvgnd_1
XTAP_TAPCELL_ROW_39_143 VSS VDD sky130_fd_sc_hd__tapvpwrvgnd_1
XTAP_TAPCELL_ROW_39_144 VSS VDD sky130_fd_sc_hd__tapvpwrvgnd_1
XTAP_TAPCELL_ROW_39_145 VSS VDD sky130_fd_sc_hd__tapvpwrvgnd_1
XTAP_TAPCELL_ROW_39_146 VSS VDD sky130_fd_sc_hd__tapvpwrvgnd_1
Xclkbuf_0_clk clk VSS VSS VDD VDD clknet_0_clk sky130_fd_sc_hd__clkbuf_16
Xclkbuf_3_0__f_clk clknet_0_clk VSS VSS VDD VDD clknet_3_0__leaf_clk
+ sky130_fd_sc_hd__clkbuf_16
Xclkbuf_3_1__f_clk clknet_0_clk VSS VSS VDD VDD clknet_3_1__leaf_clk
+ sky130_fd_sc_hd__clkbuf_16
Xclkbuf_3_2__f_clk clknet_0_clk VSS VSS VDD VDD clknet_3_2__leaf_clk
+ sky130_fd_sc_hd__clkbuf_16
Xclkbuf_3_3__f_clk clknet_0_clk VSS VSS VDD VDD clknet_3_3__leaf_clk
+ sky130_fd_sc_hd__clkbuf_16
Xclkbuf_3_4__f_clk clknet_0_clk VSS VSS VDD VDD clknet_3_4__leaf_clk
+ sky130_fd_sc_hd__clkbuf_16
Xclkbuf_3_5__f_clk clknet_0_clk VSS VSS VDD VDD clknet_3_5__leaf_clk
+ sky130_fd_sc_hd__clkbuf_16
Xclkbuf_3_6__f_clk clknet_0_clk VSS VSS VDD VDD clknet_3_6__leaf_clk
+ sky130_fd_sc_hd__clkbuf_16
Xclkbuf_3_7__f_clk clknet_0_clk VSS VSS VDD VDD clknet_3_7__leaf_clk
+ sky130_fd_sc_hd__clkbuf_16
Xclkload0 clknet_3_0__leaf_clk VSS VSS VDD VDD _unconnected_1
+ sky130_fd_sc_hd__clkbuf_8
Xclkload1 clknet_3_1__leaf_clk VSS VSS VDD VDD _unconnected_2
+ sky130_fd_sc_hd__clkinv_2
Xclkload2 clknet_3_2__leaf_clk VSS VSS VDD VDD _unconnected_3
+ sky130_fd_sc_hd__clkinvlp_4
Xclkload3 clknet_3_3__leaf_clk VSS VSS VDD VDD _unconnected_4
+ sky130_fd_sc_hd__inv_6
Xclkload4 clknet_3_4__leaf_clk VSS VSS VDD VDD _unconnected_5
+ sky130_fd_sc_hd__bufinv_16
Xclkload5 clknet_3_6__leaf_clk VSS VSS VDD VDD _unconnected_6
+ sky130_fd_sc_hd__clkinv_4
Xclkload6 clknet_3_7__leaf_clk VSS VSS VDD VDD _unconnected_7
+ sky130_fd_sc_hd__bufinv_16
XFILLER_0_0 VSS VSS VDD VDD sky130_fd_sc_hd__fill_8
XFILLER_0_8 VSS VSS VDD VDD sky130_fd_sc_hd__fill_8
XFILLER_0_16 VSS VSS VDD VDD sky130_fd_sc_hd__fill_8
XFILLER_0_24 VSS VSS VDD VDD sky130_fd_sc_hd__fill_4
XFILLER_0_28 VSS VSS VDD VDD sky130_fd_sc_hd__fill_2
XFILLER_0_47 VSS VSS VDD VDD sky130_fd_sc_hd__fill_8
XFILLER_0_55 VSS VSS VDD VDD sky130_fd_sc_hd__fill_4
XFILLER_0_59 VSS VSS VDD VDD sky130_fd_sc_hd__fill_1
XFILLER_0_61 VSS VSS VDD VDD sky130_fd_sc_hd__fill_8
XFILLER_0_69 VSS VSS VDD VDD sky130_fd_sc_hd__fill_2
XFILLER_0_87 VSS VSS VDD VDD sky130_fd_sc_hd__fill_2
XFILLER_0_89 VSS VSS VDD VDD sky130_fd_sc_hd__fill_1
XFILLER_0_91 VSS VSS VDD VDD sky130_fd_sc_hd__fill_4
XFILLER_0_95 VSS VSS VDD VDD sky130_fd_sc_hd__fill_1
XFILLER_0_112 VSS VSS VDD VDD sky130_fd_sc_hd__fill_8
XFILLER_0_121 VSS VSS VDD VDD sky130_fd_sc_hd__fill_2
XFILLER_0_123 VSS VSS VDD VDD sky130_fd_sc_hd__fill_1
XFILLER_0_127 VSS VSS VDD VDD sky130_fd_sc_hd__fill_8
XFILLER_0_135 VSS VSS VDD VDD sky130_fd_sc_hd__fill_8
XFILLER_0_143 VSS VSS VDD VDD sky130_fd_sc_hd__fill_2
XFILLER_0_145 VSS VSS VDD VDD sky130_fd_sc_hd__fill_1
XFILLER_0_149 VSS VSS VDD VDD sky130_fd_sc_hd__fill_1
XFILLER_0_151 VSS VSS VDD VDD sky130_fd_sc_hd__fill_8
XFILLER_0_159 VSS VSS VDD VDD sky130_fd_sc_hd__fill_2
XFILLER_0_161 VSS VSS VDD VDD sky130_fd_sc_hd__fill_1
XFILLER_0_165 VSS VSS VDD VDD sky130_fd_sc_hd__fill_8
XFILLER_0_173 VSS VSS VDD VDD sky130_fd_sc_hd__fill_4
XFILLER_0_177 VSS VSS VDD VDD sky130_fd_sc_hd__fill_2
XFILLER_0_179 VSS VSS VDD VDD sky130_fd_sc_hd__fill_1
XFILLER_0_181 VSS VSS VDD VDD sky130_fd_sc_hd__fill_1
XFILLER_0_185 VSS VSS VDD VDD sky130_fd_sc_hd__fill_8
XFILLER_0_193 VSS VSS VDD VDD sky130_fd_sc_hd__fill_8
XFILLER_0_201 VSS VSS VDD VDD sky130_fd_sc_hd__fill_8
XFILLER_0_209 VSS VSS VDD VDD sky130_fd_sc_hd__fill_1
XFILLER_0_211 VSS VSS VDD VDD sky130_fd_sc_hd__fill_8
XFILLER_0_219 VSS VSS VDD VDD sky130_fd_sc_hd__fill_8
XFILLER_0_227 VSS VSS VDD VDD sky130_fd_sc_hd__fill_8
XFILLER_0_235 VSS VSS VDD VDD sky130_fd_sc_hd__fill_2
XFILLER_0_237 VSS VSS VDD VDD sky130_fd_sc_hd__fill_1
XFILLER_1_0 VSS VSS VDD VDD sky130_fd_sc_hd__fill_8
XFILLER_1_24 VSS VSS VDD VDD sky130_fd_sc_hd__fill_8
XFILLER_1_32 VSS VSS VDD VDD sky130_fd_sc_hd__fill_2
XFILLER_1_53 VSS VSS VDD VDD sky130_fd_sc_hd__fill_4
XFILLER_1_57 VSS VSS VDD VDD sky130_fd_sc_hd__fill_2
XFILLER_1_59 VSS VSS VDD VDD sky130_fd_sc_hd__fill_1
XFILLER_1_65 VSS VSS VDD VDD sky130_fd_sc_hd__fill_4
XFILLER_1_69 VSS VSS VDD VDD sky130_fd_sc_hd__fill_2
XFILLER_1_71 VSS VSS VDD VDD sky130_fd_sc_hd__fill_1
XFILLER_1_94 VSS VSS VDD VDD sky130_fd_sc_hd__fill_1
XFILLER_1_98 VSS VSS VDD VDD sky130_fd_sc_hd__fill_1
XFILLER_1_118 VSS VSS VDD VDD sky130_fd_sc_hd__fill_2
XFILLER_1_137 VSS VSS VDD VDD sky130_fd_sc_hd__fill_1
XFILLER_1_154 VSS VSS VDD VDD sky130_fd_sc_hd__fill_2
XFILLER_1_156 VSS VSS VDD VDD sky130_fd_sc_hd__fill_1
XFILLER_1_173 VSS VSS VDD VDD sky130_fd_sc_hd__fill_4
XFILLER_1_197 VSS VSS VDD VDD sky130_fd_sc_hd__fill_8
XFILLER_1_205 VSS VSS VDD VDD sky130_fd_sc_hd__fill_8
XFILLER_1_213 VSS VSS VDD VDD sky130_fd_sc_hd__fill_8
XFILLER_1_221 VSS VSS VDD VDD sky130_fd_sc_hd__fill_8
XFILLER_1_229 VSS VSS VDD VDD sky130_fd_sc_hd__fill_8
XFILLER_1_237 VSS VSS VDD VDD sky130_fd_sc_hd__fill_1
XFILLER_2_0 VSS VSS VDD VDD sky130_fd_sc_hd__fill_8
XFILLER_2_8 VSS VSS VDD VDD sky130_fd_sc_hd__fill_2
XFILLER_2_29 VSS VSS VDD VDD sky130_fd_sc_hd__fill_1
XFILLER_2_31 VSS VSS VDD VDD sky130_fd_sc_hd__fill_4
XFILLER_2_39 VSS VSS VDD VDD sky130_fd_sc_hd__fill_2
XFILLER_2_73 VSS VSS VDD VDD sky130_fd_sc_hd__fill_2
XFILLER_2_75 VSS VSS VDD VDD sky130_fd_sc_hd__fill_1
XFILLER_2_80 VSS VSS VDD VDD sky130_fd_sc_hd__fill_1
XFILLER_2_84 VSS VSS VDD VDD sky130_fd_sc_hd__fill_1
XFILLER_2_89 VSS VSS VDD VDD sky130_fd_sc_hd__fill_1
XFILLER_2_91 VSS VSS VDD VDD sky130_fd_sc_hd__fill_8
XFILLER_2_99 VSS VSS VDD VDD sky130_fd_sc_hd__fill_2
XFILLER_2_148 VSS VSS VDD VDD sky130_fd_sc_hd__fill_2
XFILLER_2_151 VSS VSS VDD VDD sky130_fd_sc_hd__fill_4
XFILLER_2_171 VSS VSS VDD VDD sky130_fd_sc_hd__fill_1
XFILLER_2_196 VSS VSS VDD VDD sky130_fd_sc_hd__fill_8
XFILLER_2_204 VSS VSS VDD VDD sky130_fd_sc_hd__fill_4
XFILLER_2_208 VSS VSS VDD VDD sky130_fd_sc_hd__fill_2
XFILLER_2_211 VSS VSS VDD VDD sky130_fd_sc_hd__fill_8
XFILLER_2_219 VSS VSS VDD VDD sky130_fd_sc_hd__fill_8
XFILLER_2_227 VSS VSS VDD VDD sky130_fd_sc_hd__fill_8
XFILLER_2_235 VSS VSS VDD VDD sky130_fd_sc_hd__fill_2
XFILLER_2_237 VSS VSS VDD VDD sky130_fd_sc_hd__fill_1
XFILLER_3_0 VSS VSS VDD VDD sky130_fd_sc_hd__fill_8
XFILLER_3_8 VSS VSS VDD VDD sky130_fd_sc_hd__fill_4
XFILLER_3_12 VSS VSS VDD VDD sky130_fd_sc_hd__fill_2
XFILLER_3_25 VSS VSS VDD VDD sky130_fd_sc_hd__fill_1
XFILLER_3_42 VSS VSS VDD VDD sky130_fd_sc_hd__fill_1
XFILLER_3_47 VSS VSS VDD VDD sky130_fd_sc_hd__fill_1
XFILLER_3_51 VSS VSS VDD VDD sky130_fd_sc_hd__fill_8
XFILLER_3_59 VSS VSS VDD VDD sky130_fd_sc_hd__fill_1
XFILLER_3_67 VSS VSS VDD VDD sky130_fd_sc_hd__fill_4
XFILLER_3_71 VSS VSS VDD VDD sky130_fd_sc_hd__fill_2
XFILLER_3_73 VSS VSS VDD VDD sky130_fd_sc_hd__fill_1
XFILLER_3_77 VSS VSS VDD VDD sky130_fd_sc_hd__fill_2
XFILLER_3_82 VSS VSS VDD VDD sky130_fd_sc_hd__fill_8
XFILLER_3_90 VSS VSS VDD VDD sky130_fd_sc_hd__fill_8
XFILLER_3_98 VSS VSS VDD VDD sky130_fd_sc_hd__fill_8
XFILLER_3_106 VSS VSS VDD VDD sky130_fd_sc_hd__fill_8
XFILLER_3_114 VSS VSS VDD VDD sky130_fd_sc_hd__fill_4
XFILLER_3_118 VSS VSS VDD VDD sky130_fd_sc_hd__fill_2
XFILLER_3_131 VSS VSS VDD VDD sky130_fd_sc_hd__fill_2
XFILLER_3_133 VSS VSS VDD VDD sky130_fd_sc_hd__fill_1
XFILLER_3_138 VSS VSS VDD VDD sky130_fd_sc_hd__fill_2
XFILLER_3_140 VSS VSS VDD VDD sky130_fd_sc_hd__fill_1
XFILLER_3_144 VSS VSS VDD VDD sky130_fd_sc_hd__fill_1
XFILLER_3_149 VSS VSS VDD VDD sky130_fd_sc_hd__fill_4
XFILLER_3_153 VSS VSS VDD VDD sky130_fd_sc_hd__fill_2
XFILLER_3_158 VSS VSS VDD VDD sky130_fd_sc_hd__fill_1
XFILLER_3_170 VSS VSS VDD VDD sky130_fd_sc_hd__fill_2
XFILLER_3_175 VSS VSS VDD VDD sky130_fd_sc_hd__fill_1
XFILLER_3_197 VSS VSS VDD VDD sky130_fd_sc_hd__fill_8
XFILLER_3_205 VSS VSS VDD VDD sky130_fd_sc_hd__fill_8
XFILLER_3_213 VSS VSS VDD VDD sky130_fd_sc_hd__fill_8
XFILLER_3_221 VSS VSS VDD VDD sky130_fd_sc_hd__fill_8
XFILLER_3_229 VSS VSS VDD VDD sky130_fd_sc_hd__fill_8
XFILLER_3_237 VSS VSS VDD VDD sky130_fd_sc_hd__fill_1
XFILLER_4_0 VSS VSS VDD VDD sky130_fd_sc_hd__fill_8
XFILLER_4_8 VSS VSS VDD VDD sky130_fd_sc_hd__fill_8
XFILLER_4_16 VSS VSS VDD VDD sky130_fd_sc_hd__fill_8
XFILLER_4_24 VSS VSS VDD VDD sky130_fd_sc_hd__fill_4
XFILLER_4_28 VSS VSS VDD VDD sky130_fd_sc_hd__fill_2
XFILLER_4_35 VSS VSS VDD VDD sky130_fd_sc_hd__fill_4
XFILLER_4_42 VSS VSS VDD VDD sky130_fd_sc_hd__fill_4
XFILLER_4_46 VSS VSS VDD VDD sky130_fd_sc_hd__fill_2
XFILLER_4_48 VSS VSS VDD VDD sky130_fd_sc_hd__fill_1
XFILLER_4_52 VSS VSS VDD VDD sky130_fd_sc_hd__fill_8
XFILLER_4_63 VSS VSS VDD VDD sky130_fd_sc_hd__fill_1
XFILLER_4_67 VSS VSS VDD VDD sky130_fd_sc_hd__fill_4
XFILLER_4_87 VSS VSS VDD VDD sky130_fd_sc_hd__fill_2
XFILLER_4_89 VSS VSS VDD VDD sky130_fd_sc_hd__fill_1
XFILLER_4_94 VSS VSS VDD VDD sky130_fd_sc_hd__fill_2
XFILLER_4_100 VSS VSS VDD VDD sky130_fd_sc_hd__fill_2
XFILLER_4_102 VSS VSS VDD VDD sky130_fd_sc_hd__fill_1
XFILLER_4_106 VSS VSS VDD VDD sky130_fd_sc_hd__fill_4
XFILLER_4_110 VSS VSS VDD VDD sky130_fd_sc_hd__fill_2
XFILLER_4_112 VSS VSS VDD VDD sky130_fd_sc_hd__fill_1
XFILLER_4_129 VSS VSS VDD VDD sky130_fd_sc_hd__fill_8
XFILLER_4_137 VSS VSS VDD VDD sky130_fd_sc_hd__fill_1
XFILLER_4_141 VSS VSS VDD VDD sky130_fd_sc_hd__fill_8
XFILLER_4_149 VSS VSS VDD VDD sky130_fd_sc_hd__fill_1
XFILLER_4_154 VSS VSS VDD VDD sky130_fd_sc_hd__fill_2
XFILLER_4_162 VSS VSS VDD VDD sky130_fd_sc_hd__fill_8
XFILLER_4_170 VSS VSS VDD VDD sky130_fd_sc_hd__fill_8
XFILLER_4_178 VSS VSS VDD VDD sky130_fd_sc_hd__fill_8
XFILLER_4_186 VSS VSS VDD VDD sky130_fd_sc_hd__fill_8
XFILLER_4_194 VSS VSS VDD VDD sky130_fd_sc_hd__fill_8
XFILLER_4_202 VSS VSS VDD VDD sky130_fd_sc_hd__fill_8
XFILLER_4_211 VSS VSS VDD VDD sky130_fd_sc_hd__fill_8
XFILLER_4_219 VSS VSS VDD VDD sky130_fd_sc_hd__fill_8
XFILLER_4_227 VSS VSS VDD VDD sky130_fd_sc_hd__fill_8
XFILLER_4_235 VSS VSS VDD VDD sky130_fd_sc_hd__fill_2
XFILLER_4_237 VSS VSS VDD VDD sky130_fd_sc_hd__fill_1
XFILLER_5_0 VSS VSS VDD VDD sky130_fd_sc_hd__fill_8
XFILLER_5_8 VSS VSS VDD VDD sky130_fd_sc_hd__fill_4
XFILLER_5_12 VSS VSS VDD VDD sky130_fd_sc_hd__fill_2
XFILLER_5_14 VSS VSS VDD VDD sky130_fd_sc_hd__fill_1
XFILLER_5_18 VSS VSS VDD VDD sky130_fd_sc_hd__fill_4
XFILLER_5_25 VSS VSS VDD VDD sky130_fd_sc_hd__fill_8
XFILLER_5_33 VSS VSS VDD VDD sky130_fd_sc_hd__fill_8
XFILLER_5_41 VSS VSS VDD VDD sky130_fd_sc_hd__fill_2
XFILLER_5_43 VSS VSS VDD VDD sky130_fd_sc_hd__fill_1
XFILLER_5_61 VSS VSS VDD VDD sky130_fd_sc_hd__fill_2
XFILLER_5_124 VSS VSS VDD VDD sky130_fd_sc_hd__fill_4
XFILLER_5_170 VSS VSS VDD VDD sky130_fd_sc_hd__fill_8
XFILLER_5_178 VSS VSS VDD VDD sky130_fd_sc_hd__fill_2
XFILLER_5_181 VSS VSS VDD VDD sky130_fd_sc_hd__fill_1
XFILLER_5_198 VSS VSS VDD VDD sky130_fd_sc_hd__fill_8
XFILLER_5_206 VSS VSS VDD VDD sky130_fd_sc_hd__fill_8
XFILLER_5_214 VSS VSS VDD VDD sky130_fd_sc_hd__fill_8
XFILLER_5_222 VSS VSS VDD VDD sky130_fd_sc_hd__fill_8
XFILLER_5_230 VSS VSS VDD VDD sky130_fd_sc_hd__fill_8
XFILLER_6_0 VSS VSS VDD VDD sky130_fd_sc_hd__fill_4
XFILLER_6_23 VSS VSS VDD VDD sky130_fd_sc_hd__fill_2
XFILLER_6_29 VSS VSS VDD VDD sky130_fd_sc_hd__fill_1
XFILLER_6_35 VSS VSS VDD VDD sky130_fd_sc_hd__fill_8
XFILLER_6_43 VSS VSS VDD VDD sky130_fd_sc_hd__fill_4
XFILLER_6_89 VSS VSS VDD VDD sky130_fd_sc_hd__fill_1
XFILLER_6_91 VSS VSS VDD VDD sky130_fd_sc_hd__fill_8
XFILLER_6_99 VSS VSS VDD VDD sky130_fd_sc_hd__fill_2
XFILLER_6_101 VSS VSS VDD VDD sky130_fd_sc_hd__fill_1
XFILLER_6_121 VSS VSS VDD VDD sky130_fd_sc_hd__fill_1
XFILLER_6_197 VSS VSS VDD VDD sky130_fd_sc_hd__fill_8
XFILLER_6_205 VSS VSS VDD VDD sky130_fd_sc_hd__fill_4
XFILLER_6_209 VSS VSS VDD VDD sky130_fd_sc_hd__fill_1
XFILLER_6_211 VSS VSS VDD VDD sky130_fd_sc_hd__fill_8
XFILLER_6_219 VSS VSS VDD VDD sky130_fd_sc_hd__fill_8
XFILLER_6_227 VSS VSS VDD VDD sky130_fd_sc_hd__fill_8
XFILLER_6_235 VSS VSS VDD VDD sky130_fd_sc_hd__fill_2
XFILLER_6_237 VSS VSS VDD VDD sky130_fd_sc_hd__fill_1
XFILLER_7_0 VSS VSS VDD VDD sky130_fd_sc_hd__fill_4
XFILLER_7_42 VSS VSS VDD VDD sky130_fd_sc_hd__fill_1
XFILLER_7_59 VSS VSS VDD VDD sky130_fd_sc_hd__fill_1
XFILLER_7_76 VSS VSS VDD VDD sky130_fd_sc_hd__fill_4
XFILLER_7_83 VSS VSS VDD VDD sky130_fd_sc_hd__fill_8
XFILLER_7_91 VSS VSS VDD VDD sky130_fd_sc_hd__fill_8
XFILLER_7_99 VSS VSS VDD VDD sky130_fd_sc_hd__fill_8
XFILLER_7_107 VSS VSS VDD VDD sky130_fd_sc_hd__fill_1
XFILLER_7_111 VSS VSS VDD VDD sky130_fd_sc_hd__fill_2
XFILLER_7_113 VSS VSS VDD VDD sky130_fd_sc_hd__fill_1
XFILLER_7_117 VSS VSS VDD VDD sky130_fd_sc_hd__fill_2
XFILLER_7_119 VSS VSS VDD VDD sky130_fd_sc_hd__fill_1
XFILLER_7_121 VSS VSS VDD VDD sky130_fd_sc_hd__fill_4
XFILLER_7_125 VSS VSS VDD VDD sky130_fd_sc_hd__fill_1
XFILLER_7_163 VSS VSS VDD VDD sky130_fd_sc_hd__fill_1
XFILLER_7_181 VSS VSS VDD VDD sky130_fd_sc_hd__fill_1
XFILLER_7_189 VSS VSS VDD VDD sky130_fd_sc_hd__fill_8
XFILLER_7_197 VSS VSS VDD VDD sky130_fd_sc_hd__fill_8
XFILLER_7_205 VSS VSS VDD VDD sky130_fd_sc_hd__fill_8
XFILLER_7_213 VSS VSS VDD VDD sky130_fd_sc_hd__fill_8
XFILLER_7_221 VSS VSS VDD VDD sky130_fd_sc_hd__fill_8
XFILLER_7_229 VSS VSS VDD VDD sky130_fd_sc_hd__fill_8
XFILLER_7_237 VSS VSS VDD VDD sky130_fd_sc_hd__fill_1
XFILLER_8_0 VSS VSS VDD VDD sky130_fd_sc_hd__fill_8
XFILLER_8_8 VSS VSS VDD VDD sky130_fd_sc_hd__fill_2
XFILLER_8_10 VSS VSS VDD VDD sky130_fd_sc_hd__fill_1
XFILLER_8_19 VSS VSS VDD VDD sky130_fd_sc_hd__fill_2
XFILLER_8_24 VSS VSS VDD VDD sky130_fd_sc_hd__fill_2
XFILLER_8_31 VSS VSS VDD VDD sky130_fd_sc_hd__fill_2
XFILLER_8_37 VSS VSS VDD VDD sky130_fd_sc_hd__fill_8
XFILLER_8_45 VSS VSS VDD VDD sky130_fd_sc_hd__fill_4
XFILLER_8_49 VSS VSS VDD VDD sky130_fd_sc_hd__fill_1
XFILLER_8_70 VSS VSS VDD VDD sky130_fd_sc_hd__fill_8
XFILLER_8_78 VSS VSS VDD VDD sky130_fd_sc_hd__fill_4
XFILLER_8_82 VSS VSS VDD VDD sky130_fd_sc_hd__fill_2
XFILLER_8_88 VSS VSS VDD VDD sky130_fd_sc_hd__fill_2
XFILLER_8_94 VSS VSS VDD VDD sky130_fd_sc_hd__fill_8
XFILLER_8_102 VSS VSS VDD VDD sky130_fd_sc_hd__fill_8
XFILLER_8_110 VSS VSS VDD VDD sky130_fd_sc_hd__fill_8
XFILLER_8_118 VSS VSS VDD VDD sky130_fd_sc_hd__fill_4
XFILLER_8_122 VSS VSS VDD VDD sky130_fd_sc_hd__fill_2
XFILLER_8_124 VSS VSS VDD VDD sky130_fd_sc_hd__fill_1
XFILLER_8_128 VSS VSS VDD VDD sky130_fd_sc_hd__fill_8
XFILLER_8_143 VSS VSS VDD VDD sky130_fd_sc_hd__fill_4
XFILLER_8_147 VSS VSS VDD VDD sky130_fd_sc_hd__fill_2
XFILLER_8_149 VSS VSS VDD VDD sky130_fd_sc_hd__fill_1
XFILLER_8_171 VSS VSS VDD VDD sky130_fd_sc_hd__fill_8
XFILLER_8_179 VSS VSS VDD VDD sky130_fd_sc_hd__fill_8
XFILLER_8_187 VSS VSS VDD VDD sky130_fd_sc_hd__fill_8
XFILLER_8_195 VSS VSS VDD VDD sky130_fd_sc_hd__fill_8
XFILLER_8_203 VSS VSS VDD VDD sky130_fd_sc_hd__fill_4
XFILLER_8_207 VSS VSS VDD VDD sky130_fd_sc_hd__fill_2
XFILLER_8_209 VSS VSS VDD VDD sky130_fd_sc_hd__fill_1
XFILLER_8_211 VSS VSS VDD VDD sky130_fd_sc_hd__fill_8
XFILLER_8_219 VSS VSS VDD VDD sky130_fd_sc_hd__fill_8
XFILLER_8_227 VSS VSS VDD VDD sky130_fd_sc_hd__fill_8
XFILLER_8_235 VSS VSS VDD VDD sky130_fd_sc_hd__fill_2
XFILLER_8_237 VSS VSS VDD VDD sky130_fd_sc_hd__fill_1
XFILLER_9_0 VSS VSS VDD VDD sky130_fd_sc_hd__fill_8
XFILLER_9_8 VSS VSS VDD VDD sky130_fd_sc_hd__fill_2
XFILLER_9_14 VSS VSS VDD VDD sky130_fd_sc_hd__fill_8
XFILLER_9_22 VSS VSS VDD VDD sky130_fd_sc_hd__fill_8
XFILLER_9_30 VSS VSS VDD VDD sky130_fd_sc_hd__fill_2
XFILLER_9_32 VSS VSS VDD VDD sky130_fd_sc_hd__fill_1
XFILLER_9_36 VSS VSS VDD VDD sky130_fd_sc_hd__fill_8
XFILLER_9_44 VSS VSS VDD VDD sky130_fd_sc_hd__fill_1
XFILLER_9_61 VSS VSS VDD VDD sky130_fd_sc_hd__fill_8
XFILLER_9_69 VSS VSS VDD VDD sky130_fd_sc_hd__fill_1
XFILLER_9_74 VSS VSS VDD VDD sky130_fd_sc_hd__fill_2
XFILLER_9_76 VSS VSS VDD VDD sky130_fd_sc_hd__fill_1
XFILLER_9_93 VSS VSS VDD VDD sky130_fd_sc_hd__fill_2
XFILLER_9_113 VSS VSS VDD VDD sky130_fd_sc_hd__fill_1
XFILLER_9_117 VSS VSS VDD VDD sky130_fd_sc_hd__fill_2
XFILLER_9_119 VSS VSS VDD VDD sky130_fd_sc_hd__fill_1
XFILLER_9_121 VSS VSS VDD VDD sky130_fd_sc_hd__fill_8
XFILLER_9_129 VSS VSS VDD VDD sky130_fd_sc_hd__fill_8
XFILLER_9_137 VSS VSS VDD VDD sky130_fd_sc_hd__fill_4
XFILLER_9_141 VSS VSS VDD VDD sky130_fd_sc_hd__fill_2
XFILLER_9_147 VSS VSS VDD VDD sky130_fd_sc_hd__fill_4
XFILLER_9_151 VSS VSS VDD VDD sky130_fd_sc_hd__fill_2
XFILLER_9_160 VSS VSS VDD VDD sky130_fd_sc_hd__fill_1
XFILLER_9_168 VSS VSS VDD VDD sky130_fd_sc_hd__fill_4
XFILLER_9_172 VSS VSS VDD VDD sky130_fd_sc_hd__fill_2
XFILLER_9_181 VSS VSS VDD VDD sky130_fd_sc_hd__fill_8
XFILLER_9_192 VSS VSS VDD VDD sky130_fd_sc_hd__fill_2
XFILLER_9_194 VSS VSS VDD VDD sky130_fd_sc_hd__fill_1
XFILLER_9_198 VSS VSS VDD VDD sky130_fd_sc_hd__fill_8
XFILLER_9_206 VSS VSS VDD VDD sky130_fd_sc_hd__fill_8
XFILLER_9_214 VSS VSS VDD VDD sky130_fd_sc_hd__fill_8
XFILLER_9_222 VSS VSS VDD VDD sky130_fd_sc_hd__fill_8
XFILLER_9_230 VSS VSS VDD VDD sky130_fd_sc_hd__fill_8
XFILLER_10_0 VSS VSS VDD VDD sky130_fd_sc_hd__fill_2
XFILLER_10_2 VSS VSS VDD VDD sky130_fd_sc_hd__fill_1
XFILLER_10_22 VSS VSS VDD VDD sky130_fd_sc_hd__fill_1
XFILLER_10_41 VSS VSS VDD VDD sky130_fd_sc_hd__fill_8
XFILLER_10_49 VSS VSS VDD VDD sky130_fd_sc_hd__fill_2
XFILLER_10_57 VSS VSS VDD VDD sky130_fd_sc_hd__fill_4
XFILLER_10_61 VSS VSS VDD VDD sky130_fd_sc_hd__fill_2
XFILLER_10_82 VSS VSS VDD VDD sky130_fd_sc_hd__fill_2
XFILLER_10_91 VSS VSS VDD VDD sky130_fd_sc_hd__fill_2
XFILLER_10_98 VSS VSS VDD VDD sky130_fd_sc_hd__fill_2
XFILLER_10_131 VSS VSS VDD VDD sky130_fd_sc_hd__fill_1
XFILLER_10_143 VSS VSS VDD VDD sky130_fd_sc_hd__fill_1
XFILLER_10_183 VSS VSS VDD VDD sky130_fd_sc_hd__fill_2
XFILLER_10_201 VSS VSS VDD VDD sky130_fd_sc_hd__fill_8
XFILLER_10_209 VSS VSS VDD VDD sky130_fd_sc_hd__fill_1
XFILLER_10_211 VSS VSS VDD VDD sky130_fd_sc_hd__fill_8
XFILLER_10_219 VSS VSS VDD VDD sky130_fd_sc_hd__fill_8
XFILLER_10_227 VSS VSS VDD VDD sky130_fd_sc_hd__fill_8
XFILLER_10_235 VSS VSS VDD VDD sky130_fd_sc_hd__fill_2
XFILLER_10_237 VSS VSS VDD VDD sky130_fd_sc_hd__fill_1
XFILLER_11_0 VSS VSS VDD VDD sky130_fd_sc_hd__fill_8
XFILLER_11_8 VSS VSS VDD VDD sky130_fd_sc_hd__fill_4
XFILLER_11_12 VSS VSS VDD VDD sky130_fd_sc_hd__fill_2
XFILLER_11_14 VSS VSS VDD VDD sky130_fd_sc_hd__fill_1
XFILLER_11_24 VSS VSS VDD VDD sky130_fd_sc_hd__fill_4
XFILLER_11_28 VSS VSS VDD VDD sky130_fd_sc_hd__fill_1
XFILLER_11_32 VSS VSS VDD VDD sky130_fd_sc_hd__fill_8
XFILLER_11_40 VSS VSS VDD VDD sky130_fd_sc_hd__fill_8
XFILLER_11_48 VSS VSS VDD VDD sky130_fd_sc_hd__fill_2
XFILLER_11_53 VSS VSS VDD VDD sky130_fd_sc_hd__fill_4
XFILLER_11_57 VSS VSS VDD VDD sky130_fd_sc_hd__fill_2
XFILLER_11_59 VSS VSS VDD VDD sky130_fd_sc_hd__fill_1
XFILLER_11_61 VSS VSS VDD VDD sky130_fd_sc_hd__fill_8
XFILLER_11_86 VSS VSS VDD VDD sky130_fd_sc_hd__fill_4
XFILLER_11_90 VSS VSS VDD VDD sky130_fd_sc_hd__fill_1
XFILLER_11_102 VSS VSS VDD VDD sky130_fd_sc_hd__fill_4
XFILLER_11_106 VSS VSS VDD VDD sky130_fd_sc_hd__fill_2
XFILLER_11_108 VSS VSS VDD VDD sky130_fd_sc_hd__fill_1
XFILLER_11_112 VSS VSS VDD VDD sky130_fd_sc_hd__fill_2
XFILLER_11_137 VSS VSS VDD VDD sky130_fd_sc_hd__fill_1
XFILLER_11_145 VSS VSS VDD VDD sky130_fd_sc_hd__fill_2
XFILLER_11_147 VSS VSS VDD VDD sky130_fd_sc_hd__fill_1
XFILLER_11_168 VSS VSS VDD VDD sky130_fd_sc_hd__fill_8
XFILLER_11_176 VSS VSS VDD VDD sky130_fd_sc_hd__fill_4
XFILLER_11_181 VSS VSS VDD VDD sky130_fd_sc_hd__fill_1
XFILLER_11_201 VSS VSS VDD VDD sky130_fd_sc_hd__fill_8
XFILLER_11_209 VSS VSS VDD VDD sky130_fd_sc_hd__fill_8
XFILLER_11_217 VSS VSS VDD VDD sky130_fd_sc_hd__fill_8
XFILLER_11_225 VSS VSS VDD VDD sky130_fd_sc_hd__fill_8
XFILLER_11_233 VSS VSS VDD VDD sky130_fd_sc_hd__fill_4
XFILLER_11_237 VSS VSS VDD VDD sky130_fd_sc_hd__fill_1
XFILLER_12_0 VSS VSS VDD VDD sky130_fd_sc_hd__fill_8
XFILLER_12_8 VSS VSS VDD VDD sky130_fd_sc_hd__fill_8
XFILLER_12_16 VSS VSS VDD VDD sky130_fd_sc_hd__fill_4
XFILLER_12_28 VSS VSS VDD VDD sky130_fd_sc_hd__fill_2
XFILLER_12_35 VSS VSS VDD VDD sky130_fd_sc_hd__fill_4
XFILLER_12_39 VSS VSS VDD VDD sky130_fd_sc_hd__fill_2
XFILLER_12_41 VSS VSS VDD VDD sky130_fd_sc_hd__fill_1
XFILLER_12_46 VSS VSS VDD VDD sky130_fd_sc_hd__fill_4
XFILLER_12_68 VSS VSS VDD VDD sky130_fd_sc_hd__fill_8
XFILLER_12_81 VSS VSS VDD VDD sky130_fd_sc_hd__fill_8
XFILLER_12_89 VSS VSS VDD VDD sky130_fd_sc_hd__fill_1
XFILLER_12_99 VSS VSS VDD VDD sky130_fd_sc_hd__fill_2
XFILLER_12_109 VSS VSS VDD VDD sky130_fd_sc_hd__fill_4
XFILLER_12_144 VSS VSS VDD VDD sky130_fd_sc_hd__fill_4
XFILLER_12_148 VSS VSS VDD VDD sky130_fd_sc_hd__fill_2
XFILLER_12_155 VSS VSS VDD VDD sky130_fd_sc_hd__fill_8
XFILLER_12_166 VSS VSS VDD VDD sky130_fd_sc_hd__fill_4
XFILLER_12_170 VSS VSS VDD VDD sky130_fd_sc_hd__fill_2
XFILLER_12_172 VSS VSS VDD VDD sky130_fd_sc_hd__fill_1
XFILLER_12_177 VSS VSS VDD VDD sky130_fd_sc_hd__fill_4
XFILLER_12_187 VSS VSS VDD VDD sky130_fd_sc_hd__fill_2
XFILLER_12_189 VSS VSS VDD VDD sky130_fd_sc_hd__fill_1
XFILLER_12_193 VSS VSS VDD VDD sky130_fd_sc_hd__fill_8
XFILLER_12_201 VSS VSS VDD VDD sky130_fd_sc_hd__fill_8
XFILLER_12_209 VSS VSS VDD VDD sky130_fd_sc_hd__fill_1
XFILLER_12_211 VSS VSS VDD VDD sky130_fd_sc_hd__fill_8
XFILLER_12_219 VSS VSS VDD VDD sky130_fd_sc_hd__fill_8
XFILLER_12_227 VSS VSS VDD VDD sky130_fd_sc_hd__fill_8
XFILLER_12_235 VSS VSS VDD VDD sky130_fd_sc_hd__fill_2
XFILLER_12_237 VSS VSS VDD VDD sky130_fd_sc_hd__fill_1
XFILLER_13_0 VSS VSS VDD VDD sky130_fd_sc_hd__fill_8
XFILLER_13_8 VSS VSS VDD VDD sky130_fd_sc_hd__fill_4
XFILLER_13_12 VSS VSS VDD VDD sky130_fd_sc_hd__fill_2
XFILLER_13_14 VSS VSS VDD VDD sky130_fd_sc_hd__fill_1
XFILLER_13_38 VSS VSS VDD VDD sky130_fd_sc_hd__fill_8
XFILLER_13_46 VSS VSS VDD VDD sky130_fd_sc_hd__fill_4
XFILLER_13_69 VSS VSS VDD VDD sky130_fd_sc_hd__fill_8
XFILLER_13_77 VSS VSS VDD VDD sky130_fd_sc_hd__fill_2
XFILLER_13_116 VSS VSS VDD VDD sky130_fd_sc_hd__fill_4
XFILLER_13_121 VSS VSS VDD VDD sky130_fd_sc_hd__fill_8
XFILLER_13_129 VSS VSS VDD VDD sky130_fd_sc_hd__fill_4
XFILLER_13_140 VSS VSS VDD VDD sky130_fd_sc_hd__fill_4
XFILLER_13_144 VSS VSS VDD VDD sky130_fd_sc_hd__fill_2
XFILLER_13_146 VSS VSS VDD VDD sky130_fd_sc_hd__fill_1
XFILLER_13_161 VSS VSS VDD VDD sky130_fd_sc_hd__fill_8
XFILLER_13_169 VSS VSS VDD VDD sky130_fd_sc_hd__fill_2
XFILLER_13_178 VSS VSS VDD VDD sky130_fd_sc_hd__fill_2
XFILLER_13_184 VSS VSS VDD VDD sky130_fd_sc_hd__fill_8
XFILLER_13_192 VSS VSS VDD VDD sky130_fd_sc_hd__fill_4
XFILLER_13_196 VSS VSS VDD VDD sky130_fd_sc_hd__fill_2
XFILLER_13_198 VSS VSS VDD VDD sky130_fd_sc_hd__fill_1
XFILLER_13_202 VSS VSS VDD VDD sky130_fd_sc_hd__fill_8
XFILLER_13_210 VSS VSS VDD VDD sky130_fd_sc_hd__fill_8
XFILLER_13_218 VSS VSS VDD VDD sky130_fd_sc_hd__fill_8
XFILLER_13_226 VSS VSS VDD VDD sky130_fd_sc_hd__fill_8
XFILLER_13_234 VSS VSS VDD VDD sky130_fd_sc_hd__fill_4
XFILLER_14_0 VSS VSS VDD VDD sky130_fd_sc_hd__fill_8
XFILLER_14_8 VSS VSS VDD VDD sky130_fd_sc_hd__fill_4
XFILLER_14_20 VSS VSS VDD VDD sky130_fd_sc_hd__fill_1
XFILLER_14_29 VSS VSS VDD VDD sky130_fd_sc_hd__fill_1
XFILLER_14_36 VSS VSS VDD VDD sky130_fd_sc_hd__fill_8
XFILLER_14_44 VSS VSS VDD VDD sky130_fd_sc_hd__fill_4
XFILLER_14_48 VSS VSS VDD VDD sky130_fd_sc_hd__fill_2
XFILLER_14_50 VSS VSS VDD VDD sky130_fd_sc_hd__fill_1
XFILLER_14_64 VSS VSS VDD VDD sky130_fd_sc_hd__fill_8
XFILLER_14_72 VSS VSS VDD VDD sky130_fd_sc_hd__fill_4
XFILLER_14_76 VSS VSS VDD VDD sky130_fd_sc_hd__fill_1
XFILLER_14_89 VSS VSS VDD VDD sky130_fd_sc_hd__fill_1
XFILLER_14_98 VSS VSS VDD VDD sky130_fd_sc_hd__fill_1
XFILLER_14_119 VSS VSS VDD VDD sky130_fd_sc_hd__fill_8
XFILLER_14_127 VSS VSS VDD VDD sky130_fd_sc_hd__fill_8
XFILLER_14_135 VSS VSS VDD VDD sky130_fd_sc_hd__fill_8
XFILLER_14_143 VSS VSS VDD VDD sky130_fd_sc_hd__fill_2
XFILLER_14_145 VSS VSS VDD VDD sky130_fd_sc_hd__fill_1
XFILLER_14_155 VSS VSS VDD VDD sky130_fd_sc_hd__fill_8
XFILLER_14_163 VSS VSS VDD VDD sky130_fd_sc_hd__fill_8
XFILLER_14_187 VSS VSS VDD VDD sky130_fd_sc_hd__fill_4
XFILLER_14_207 VSS VSS VDD VDD sky130_fd_sc_hd__fill_2
XFILLER_14_209 VSS VSS VDD VDD sky130_fd_sc_hd__fill_1
XFILLER_14_211 VSS VSS VDD VDD sky130_fd_sc_hd__fill_8
XFILLER_14_219 VSS VSS VDD VDD sky130_fd_sc_hd__fill_8
XFILLER_14_227 VSS VSS VDD VDD sky130_fd_sc_hd__fill_8
XFILLER_14_235 VSS VSS VDD VDD sky130_fd_sc_hd__fill_2
XFILLER_14_237 VSS VSS VDD VDD sky130_fd_sc_hd__fill_1
XFILLER_15_0 VSS VSS VDD VDD sky130_fd_sc_hd__fill_4
XFILLER_15_4 VSS VSS VDD VDD sky130_fd_sc_hd__fill_2
XFILLER_15_6 VSS VSS VDD VDD sky130_fd_sc_hd__fill_1
XFILLER_15_26 VSS VSS VDD VDD sky130_fd_sc_hd__fill_2
XFILLER_15_31 VSS VSS VDD VDD sky130_fd_sc_hd__fill_4
XFILLER_15_35 VSS VSS VDD VDD sky130_fd_sc_hd__fill_2
XFILLER_15_40 VSS VSS VDD VDD sky130_fd_sc_hd__fill_4
XFILLER_15_44 VSS VSS VDD VDD sky130_fd_sc_hd__fill_2
XFILLER_15_46 VSS VSS VDD VDD sky130_fd_sc_hd__fill_1
XFILLER_15_56 VSS VSS VDD VDD sky130_fd_sc_hd__fill_4
XFILLER_15_61 VSS VSS VDD VDD sky130_fd_sc_hd__fill_8
XFILLER_15_69 VSS VSS VDD VDD sky130_fd_sc_hd__fill_8
XFILLER_15_77 VSS VSS VDD VDD sky130_fd_sc_hd__fill_4
XFILLER_15_84 VSS VSS VDD VDD sky130_fd_sc_hd__fill_4
XFILLER_15_108 VSS VSS VDD VDD sky130_fd_sc_hd__fill_8
XFILLER_15_116 VSS VSS VDD VDD sky130_fd_sc_hd__fill_1
XFILLER_15_121 VSS VSS VDD VDD sky130_fd_sc_hd__fill_2
XFILLER_15_123 VSS VSS VDD VDD sky130_fd_sc_hd__fill_1
XFILLER_15_132 VSS VSS VDD VDD sky130_fd_sc_hd__fill_2
XFILLER_15_134 VSS VSS VDD VDD sky130_fd_sc_hd__fill_1
XFILLER_15_142 VSS VSS VDD VDD sky130_fd_sc_hd__fill_4
XFILLER_15_146 VSS VSS VDD VDD sky130_fd_sc_hd__fill_2
XFILLER_15_148 VSS VSS VDD VDD sky130_fd_sc_hd__fill_1
XFILLER_15_163 VSS VSS VDD VDD sky130_fd_sc_hd__fill_8
XFILLER_15_171 VSS VSS VDD VDD sky130_fd_sc_hd__fill_4
XFILLER_15_175 VSS VSS VDD VDD sky130_fd_sc_hd__fill_1
XFILLER_15_181 VSS VSS VDD VDD sky130_fd_sc_hd__fill_1
XFILLER_15_205 VSS VSS VDD VDD sky130_fd_sc_hd__fill_8
XFILLER_15_213 VSS VSS VDD VDD sky130_fd_sc_hd__fill_8
XFILLER_15_221 VSS VSS VDD VDD sky130_fd_sc_hd__fill_8
XFILLER_15_229 VSS VSS VDD VDD sky130_fd_sc_hd__fill_8
XFILLER_15_237 VSS VSS VDD VDD sky130_fd_sc_hd__fill_1
XFILLER_16_0 VSS VSS VDD VDD sky130_fd_sc_hd__fill_8
XFILLER_16_20 VSS VSS VDD VDD sky130_fd_sc_hd__fill_8
XFILLER_16_28 VSS VSS VDD VDD sky130_fd_sc_hd__fill_2
XFILLER_16_31 VSS VSS VDD VDD sky130_fd_sc_hd__fill_8
XFILLER_16_39 VSS VSS VDD VDD sky130_fd_sc_hd__fill_4
XFILLER_16_48 VSS VSS VDD VDD sky130_fd_sc_hd__fill_4
XFILLER_16_55 VSS VSS VDD VDD sky130_fd_sc_hd__fill_8
XFILLER_16_63 VSS VSS VDD VDD sky130_fd_sc_hd__fill_8
XFILLER_16_71 VSS VSS VDD VDD sky130_fd_sc_hd__fill_4
XFILLER_16_108 VSS VSS VDD VDD sky130_fd_sc_hd__fill_4
XFILLER_16_112 VSS VSS VDD VDD sky130_fd_sc_hd__fill_2
XFILLER_16_121 VSS VSS VDD VDD sky130_fd_sc_hd__fill_2
XFILLER_16_135 VSS VSS VDD VDD sky130_fd_sc_hd__fill_8
XFILLER_16_143 VSS VSS VDD VDD sky130_fd_sc_hd__fill_4
XFILLER_16_151 VSS VSS VDD VDD sky130_fd_sc_hd__fill_2
XFILLER_16_209 VSS VSS VDD VDD sky130_fd_sc_hd__fill_1
XFILLER_16_211 VSS VSS VDD VDD sky130_fd_sc_hd__fill_8
XFILLER_16_219 VSS VSS VDD VDD sky130_fd_sc_hd__fill_8
XFILLER_16_227 VSS VSS VDD VDD sky130_fd_sc_hd__fill_8
XFILLER_16_235 VSS VSS VDD VDD sky130_fd_sc_hd__fill_2
XFILLER_16_237 VSS VSS VDD VDD sky130_fd_sc_hd__fill_1
XFILLER_17_0 VSS VSS VDD VDD sky130_fd_sc_hd__fill_2
XFILLER_17_2 VSS VSS VDD VDD sky130_fd_sc_hd__fill_1
XFILLER_17_22 VSS VSS VDD VDD sky130_fd_sc_hd__fill_4
XFILLER_17_26 VSS VSS VDD VDD sky130_fd_sc_hd__fill_2
XFILLER_17_40 VSS VSS VDD VDD sky130_fd_sc_hd__fill_1
XFILLER_17_56 VSS VSS VDD VDD sky130_fd_sc_hd__fill_1
XFILLER_17_68 VSS VSS VDD VDD sky130_fd_sc_hd__fill_2
XFILLER_17_73 VSS VSS VDD VDD sky130_fd_sc_hd__fill_2
XFILLER_17_75 VSS VSS VDD VDD sky130_fd_sc_hd__fill_1
XFILLER_17_79 VSS VSS VDD VDD sky130_fd_sc_hd__fill_1
XFILLER_17_87 VSS VSS VDD VDD sky130_fd_sc_hd__fill_8
XFILLER_17_95 VSS VSS VDD VDD sky130_fd_sc_hd__fill_1
XFILLER_17_103 VSS VSS VDD VDD sky130_fd_sc_hd__fill_2
XFILLER_17_105 VSS VSS VDD VDD sky130_fd_sc_hd__fill_1
XFILLER_17_117 VSS VSS VDD VDD sky130_fd_sc_hd__fill_2
XFILLER_17_119 VSS VSS VDD VDD sky130_fd_sc_hd__fill_1
XFILLER_17_121 VSS VSS VDD VDD sky130_fd_sc_hd__fill_1
XFILLER_17_125 VSS VSS VDD VDD sky130_fd_sc_hd__fill_2
XFILLER_17_131 VSS VSS VDD VDD sky130_fd_sc_hd__fill_2
XFILLER_17_133 VSS VSS VDD VDD sky130_fd_sc_hd__fill_1
XFILLER_17_137 VSS VSS VDD VDD sky130_fd_sc_hd__fill_8
XFILLER_17_145 VSS VSS VDD VDD sky130_fd_sc_hd__fill_1
XFILLER_17_173 VSS VSS VDD VDD sky130_fd_sc_hd__fill_4
XFILLER_17_177 VSS VSS VDD VDD sky130_fd_sc_hd__fill_2
XFILLER_17_179 VSS VSS VDD VDD sky130_fd_sc_hd__fill_1
XFILLER_17_188 VSS VSS VDD VDD sky130_fd_sc_hd__fill_8
XFILLER_17_196 VSS VSS VDD VDD sky130_fd_sc_hd__fill_2
XFILLER_17_198 VSS VSS VDD VDD sky130_fd_sc_hd__fill_1
XFILLER_17_202 VSS VSS VDD VDD sky130_fd_sc_hd__fill_8
XFILLER_17_210 VSS VSS VDD VDD sky130_fd_sc_hd__fill_8
XFILLER_17_218 VSS VSS VDD VDD sky130_fd_sc_hd__fill_8
XFILLER_17_226 VSS VSS VDD VDD sky130_fd_sc_hd__fill_8
XFILLER_17_234 VSS VSS VDD VDD sky130_fd_sc_hd__fill_4
XFILLER_18_0 VSS VSS VDD VDD sky130_fd_sc_hd__fill_8
XFILLER_18_8 VSS VSS VDD VDD sky130_fd_sc_hd__fill_4
XFILLER_18_21 VSS VSS VDD VDD sky130_fd_sc_hd__fill_4
XFILLER_18_25 VSS VSS VDD VDD sky130_fd_sc_hd__fill_1
XFILLER_18_31 VSS VSS VDD VDD sky130_fd_sc_hd__fill_2
XFILLER_18_33 VSS VSS VDD VDD sky130_fd_sc_hd__fill_1
XFILLER_18_72 VSS VSS VDD VDD sky130_fd_sc_hd__fill_1
XFILLER_18_79 VSS VSS VDD VDD sky130_fd_sc_hd__fill_8
XFILLER_18_87 VSS VSS VDD VDD sky130_fd_sc_hd__fill_2
XFILLER_18_89 VSS VSS VDD VDD sky130_fd_sc_hd__fill_1
XFILLER_18_91 VSS VSS VDD VDD sky130_fd_sc_hd__fill_2
XFILLER_18_93 VSS VSS VDD VDD sky130_fd_sc_hd__fill_1
XFILLER_18_117 VSS VSS VDD VDD sky130_fd_sc_hd__fill_2
XFILLER_18_126 VSS VSS VDD VDD sky130_fd_sc_hd__fill_1
XFILLER_18_151 VSS VSS VDD VDD sky130_fd_sc_hd__fill_2
XFILLER_18_177 VSS VSS VDD VDD sky130_fd_sc_hd__fill_8
XFILLER_18_185 VSS VSS VDD VDD sky130_fd_sc_hd__fill_1
XFILLER_18_208 VSS VSS VDD VDD sky130_fd_sc_hd__fill_2
XFILLER_18_211 VSS VSS VDD VDD sky130_fd_sc_hd__fill_8
XFILLER_18_219 VSS VSS VDD VDD sky130_fd_sc_hd__fill_8
XFILLER_18_227 VSS VSS VDD VDD sky130_fd_sc_hd__fill_8
XFILLER_18_235 VSS VSS VDD VDD sky130_fd_sc_hd__fill_2
XFILLER_18_237 VSS VSS VDD VDD sky130_fd_sc_hd__fill_1
XFILLER_19_0 VSS VSS VDD VDD sky130_fd_sc_hd__fill_2
XFILLER_19_2 VSS VSS VDD VDD sky130_fd_sc_hd__fill_1
XFILLER_19_22 VSS VSS VDD VDD sky130_fd_sc_hd__fill_1
XFILLER_19_39 VSS VSS VDD VDD sky130_fd_sc_hd__fill_1
XFILLER_19_58 VSS VSS VDD VDD sky130_fd_sc_hd__fill_2
XFILLER_19_67 VSS VSS VDD VDD sky130_fd_sc_hd__fill_1
XFILLER_19_82 VSS VSS VDD VDD sky130_fd_sc_hd__fill_8
XFILLER_19_90 VSS VSS VDD VDD sky130_fd_sc_hd__fill_8
XFILLER_19_98 VSS VSS VDD VDD sky130_fd_sc_hd__fill_4
XFILLER_19_102 VSS VSS VDD VDD sky130_fd_sc_hd__fill_2
XFILLER_19_114 VSS VSS VDD VDD sky130_fd_sc_hd__fill_4
XFILLER_19_118 VSS VSS VDD VDD sky130_fd_sc_hd__fill_2
XFILLER_19_121 VSS VSS VDD VDD sky130_fd_sc_hd__fill_8
XFILLER_19_129 VSS VSS VDD VDD sky130_fd_sc_hd__fill_2
XFILLER_19_163 VSS VSS VDD VDD sky130_fd_sc_hd__fill_4
XFILLER_19_167 VSS VSS VDD VDD sky130_fd_sc_hd__fill_1
XFILLER_19_177 VSS VSS VDD VDD sky130_fd_sc_hd__fill_2
XFILLER_19_179 VSS VSS VDD VDD sky130_fd_sc_hd__fill_1
XFILLER_19_181 VSS VSS VDD VDD sky130_fd_sc_hd__fill_1
XFILLER_19_195 VSS VSS VDD VDD sky130_fd_sc_hd__fill_8
XFILLER_19_203 VSS VSS VDD VDD sky130_fd_sc_hd__fill_8
XFILLER_19_211 VSS VSS VDD VDD sky130_fd_sc_hd__fill_8
XFILLER_19_219 VSS VSS VDD VDD sky130_fd_sc_hd__fill_8
XFILLER_19_227 VSS VSS VDD VDD sky130_fd_sc_hd__fill_8
XFILLER_19_235 VSS VSS VDD VDD sky130_fd_sc_hd__fill_2
XFILLER_19_237 VSS VSS VDD VDD sky130_fd_sc_hd__fill_1
XFILLER_20_0 VSS VSS VDD VDD sky130_fd_sc_hd__fill_8
XFILLER_20_8 VSS VSS VDD VDD sky130_fd_sc_hd__fill_4
XFILLER_20_16 VSS VSS VDD VDD sky130_fd_sc_hd__fill_4
XFILLER_20_24 VSS VSS VDD VDD sky130_fd_sc_hd__fill_4
XFILLER_20_28 VSS VSS VDD VDD sky130_fd_sc_hd__fill_2
XFILLER_20_31 VSS VSS VDD VDD sky130_fd_sc_hd__fill_2
XFILLER_20_36 VSS VSS VDD VDD sky130_fd_sc_hd__fill_8
XFILLER_20_44 VSS VSS VDD VDD sky130_fd_sc_hd__fill_1
XFILLER_20_49 VSS VSS VDD VDD sky130_fd_sc_hd__fill_8
XFILLER_20_57 VSS VSS VDD VDD sky130_fd_sc_hd__fill_2
XFILLER_20_66 VSS VSS VDD VDD sky130_fd_sc_hd__fill_8
XFILLER_20_74 VSS VSS VDD VDD sky130_fd_sc_hd__fill_8
XFILLER_20_82 VSS VSS VDD VDD sky130_fd_sc_hd__fill_1
XFILLER_20_87 VSS VSS VDD VDD sky130_fd_sc_hd__fill_2
XFILLER_20_89 VSS VSS VDD VDD sky130_fd_sc_hd__fill_1
XFILLER_20_91 VSS VSS VDD VDD sky130_fd_sc_hd__fill_8
XFILLER_20_99 VSS VSS VDD VDD sky130_fd_sc_hd__fill_4
XFILLER_20_103 VSS VSS VDD VDD sky130_fd_sc_hd__fill_2
XFILLER_20_105 VSS VSS VDD VDD sky130_fd_sc_hd__fill_1
XFILLER_20_113 VSS VSS VDD VDD sky130_fd_sc_hd__fill_8
XFILLER_20_121 VSS VSS VDD VDD sky130_fd_sc_hd__fill_2
XFILLER_20_123 VSS VSS VDD VDD sky130_fd_sc_hd__fill_1
XFILLER_20_144 VSS VSS VDD VDD sky130_fd_sc_hd__fill_4
XFILLER_20_148 VSS VSS VDD VDD sky130_fd_sc_hd__fill_2
XFILLER_20_151 VSS VSS VDD VDD sky130_fd_sc_hd__fill_2
XFILLER_20_153 VSS VSS VDD VDD sky130_fd_sc_hd__fill_1
XFILLER_20_157 VSS VSS VDD VDD sky130_fd_sc_hd__fill_8
XFILLER_20_165 VSS VSS VDD VDD sky130_fd_sc_hd__fill_1
XFILLER_20_173 VSS VSS VDD VDD sky130_fd_sc_hd__fill_2
XFILLER_20_195 VSS VSS VDD VDD sky130_fd_sc_hd__fill_8
XFILLER_20_203 VSS VSS VDD VDD sky130_fd_sc_hd__fill_4
XFILLER_20_207 VSS VSS VDD VDD sky130_fd_sc_hd__fill_2
XFILLER_20_209 VSS VSS VDD VDD sky130_fd_sc_hd__fill_1
XFILLER_20_211 VSS VSS VDD VDD sky130_fd_sc_hd__fill_8
XFILLER_20_219 VSS VSS VDD VDD sky130_fd_sc_hd__fill_8
XFILLER_20_227 VSS VSS VDD VDD sky130_fd_sc_hd__fill_8
XFILLER_20_235 VSS VSS VDD VDD sky130_fd_sc_hd__fill_2
XFILLER_20_237 VSS VSS VDD VDD sky130_fd_sc_hd__fill_1
XFILLER_21_0 VSS VSS VDD VDD sky130_fd_sc_hd__fill_8
XFILLER_21_8 VSS VSS VDD VDD sky130_fd_sc_hd__fill_8
XFILLER_21_16 VSS VSS VDD VDD sky130_fd_sc_hd__fill_2
XFILLER_21_29 VSS VSS VDD VDD sky130_fd_sc_hd__fill_8
XFILLER_21_37 VSS VSS VDD VDD sky130_fd_sc_hd__fill_8
XFILLER_21_45 VSS VSS VDD VDD sky130_fd_sc_hd__fill_8
XFILLER_21_53 VSS VSS VDD VDD sky130_fd_sc_hd__fill_4
XFILLER_21_57 VSS VSS VDD VDD sky130_fd_sc_hd__fill_2
XFILLER_21_59 VSS VSS VDD VDD sky130_fd_sc_hd__fill_1
XFILLER_21_61 VSS VSS VDD VDD sky130_fd_sc_hd__fill_2
XFILLER_21_63 VSS VSS VDD VDD sky130_fd_sc_hd__fill_1
XFILLER_21_71 VSS VSS VDD VDD sky130_fd_sc_hd__fill_8
XFILLER_21_79 VSS VSS VDD VDD sky130_fd_sc_hd__fill_4
XFILLER_21_83 VSS VSS VDD VDD sky130_fd_sc_hd__fill_2
XFILLER_21_98 VSS VSS VDD VDD sky130_fd_sc_hd__fill_4
XFILLER_21_115 VSS VSS VDD VDD sky130_fd_sc_hd__fill_4
XFILLER_21_119 VSS VSS VDD VDD sky130_fd_sc_hd__fill_1
XFILLER_21_121 VSS VSS VDD VDD sky130_fd_sc_hd__fill_1
XFILLER_21_149 VSS VSS VDD VDD sky130_fd_sc_hd__fill_2
XFILLER_21_154 VSS VSS VDD VDD sky130_fd_sc_hd__fill_4
XFILLER_21_169 VSS VSS VDD VDD sky130_fd_sc_hd__fill_2
XFILLER_21_171 VSS VSS VDD VDD sky130_fd_sc_hd__fill_1
XFILLER_21_176 VSS VSS VDD VDD sky130_fd_sc_hd__fill_4
XFILLER_21_189 VSS VSS VDD VDD sky130_fd_sc_hd__fill_8
XFILLER_21_197 VSS VSS VDD VDD sky130_fd_sc_hd__fill_8
XFILLER_21_205 VSS VSS VDD VDD sky130_fd_sc_hd__fill_8
XFILLER_21_213 VSS VSS VDD VDD sky130_fd_sc_hd__fill_8
XFILLER_21_221 VSS VSS VDD VDD sky130_fd_sc_hd__fill_8
XFILLER_21_229 VSS VSS VDD VDD sky130_fd_sc_hd__fill_8
XFILLER_21_237 VSS VSS VDD VDD sky130_fd_sc_hd__fill_1
XFILLER_22_0 VSS VSS VDD VDD sky130_fd_sc_hd__fill_8
XFILLER_22_8 VSS VSS VDD VDD sky130_fd_sc_hd__fill_2
XFILLER_22_10 VSS VSS VDD VDD sky130_fd_sc_hd__fill_1
XFILLER_22_15 VSS VSS VDD VDD sky130_fd_sc_hd__fill_1
XFILLER_22_31 VSS VSS VDD VDD sky130_fd_sc_hd__fill_8
XFILLER_22_39 VSS VSS VDD VDD sky130_fd_sc_hd__fill_2
XFILLER_22_41 VSS VSS VDD VDD sky130_fd_sc_hd__fill_1
XFILLER_22_52 VSS VSS VDD VDD sky130_fd_sc_hd__fill_2
XFILLER_22_63 VSS VSS VDD VDD sky130_fd_sc_hd__fill_2
XFILLER_22_73 VSS VSS VDD VDD sky130_fd_sc_hd__fill_2
XFILLER_22_79 VSS VSS VDD VDD sky130_fd_sc_hd__fill_4
XFILLER_22_89 VSS VSS VDD VDD sky130_fd_sc_hd__fill_1
XFILLER_22_91 VSS VSS VDD VDD sky130_fd_sc_hd__fill_1
XFILLER_22_117 VSS VSS VDD VDD sky130_fd_sc_hd__fill_8
XFILLER_22_142 VSS VSS VDD VDD sky130_fd_sc_hd__fill_8
XFILLER_22_151 VSS VSS VDD VDD sky130_fd_sc_hd__fill_4
XFILLER_22_155 VSS VSS VDD VDD sky130_fd_sc_hd__fill_2
XFILLER_22_157 VSS VSS VDD VDD sky130_fd_sc_hd__fill_1
XFILLER_22_161 VSS VSS VDD VDD sky130_fd_sc_hd__fill_8
XFILLER_22_169 VSS VSS VDD VDD sky130_fd_sc_hd__fill_8
XFILLER_22_177 VSS VSS VDD VDD sky130_fd_sc_hd__fill_4
XFILLER_22_181 VSS VSS VDD VDD sky130_fd_sc_hd__fill_1
XFILLER_22_190 VSS VSS VDD VDD sky130_fd_sc_hd__fill_8
XFILLER_22_198 VSS VSS VDD VDD sky130_fd_sc_hd__fill_8
XFILLER_22_206 VSS VSS VDD VDD sky130_fd_sc_hd__fill_4
XFILLER_22_211 VSS VSS VDD VDD sky130_fd_sc_hd__fill_8
XFILLER_22_219 VSS VSS VDD VDD sky130_fd_sc_hd__fill_8
XFILLER_22_227 VSS VSS VDD VDD sky130_fd_sc_hd__fill_8
XFILLER_22_235 VSS VSS VDD VDD sky130_fd_sc_hd__fill_2
XFILLER_22_237 VSS VSS VDD VDD sky130_fd_sc_hd__fill_1
XFILLER_23_0 VSS VSS VDD VDD sky130_fd_sc_hd__fill_2
XFILLER_23_2 VSS VSS VDD VDD sky130_fd_sc_hd__fill_1
XFILLER_23_26 VSS VSS VDD VDD sky130_fd_sc_hd__fill_8
XFILLER_23_34 VSS VSS VDD VDD sky130_fd_sc_hd__fill_8
XFILLER_23_42 VSS VSS VDD VDD sky130_fd_sc_hd__fill_2
XFILLER_23_44 VSS VSS VDD VDD sky130_fd_sc_hd__fill_1
XFILLER_23_57 VSS VSS VDD VDD sky130_fd_sc_hd__fill_2
XFILLER_23_59 VSS VSS VDD VDD sky130_fd_sc_hd__fill_1
XFILLER_23_61 VSS VSS VDD VDD sky130_fd_sc_hd__fill_1
XFILLER_23_65 VSS VSS VDD VDD sky130_fd_sc_hd__fill_8
XFILLER_23_73 VSS VSS VDD VDD sky130_fd_sc_hd__fill_8
XFILLER_23_81 VSS VSS VDD VDD sky130_fd_sc_hd__fill_1
XFILLER_23_90 VSS VSS VDD VDD sky130_fd_sc_hd__fill_2
XFILLER_23_95 VSS VSS VDD VDD sky130_fd_sc_hd__fill_4
XFILLER_23_99 VSS VSS VDD VDD sky130_fd_sc_hd__fill_2
XFILLER_23_111 VSS VSS VDD VDD sky130_fd_sc_hd__fill_8
XFILLER_23_119 VSS VSS VDD VDD sky130_fd_sc_hd__fill_1
XFILLER_23_121 VSS VSS VDD VDD sky130_fd_sc_hd__fill_1
XFILLER_23_125 VSS VSS VDD VDD sky130_fd_sc_hd__fill_2
XFILLER_23_137 VSS VSS VDD VDD sky130_fd_sc_hd__fill_8
XFILLER_23_145 VSS VSS VDD VDD sky130_fd_sc_hd__fill_8
XFILLER_23_153 VSS VSS VDD VDD sky130_fd_sc_hd__fill_2
XFILLER_23_167 VSS VSS VDD VDD sky130_fd_sc_hd__fill_8
XFILLER_23_175 VSS VSS VDD VDD sky130_fd_sc_hd__fill_4
XFILLER_23_179 VSS VSS VDD VDD sky130_fd_sc_hd__fill_1
XFILLER_23_193 VSS VSS VDD VDD sky130_fd_sc_hd__fill_8
XFILLER_23_201 VSS VSS VDD VDD sky130_fd_sc_hd__fill_8
XFILLER_23_209 VSS VSS VDD VDD sky130_fd_sc_hd__fill_8
XFILLER_23_217 VSS VSS VDD VDD sky130_fd_sc_hd__fill_8
XFILLER_23_225 VSS VSS VDD VDD sky130_fd_sc_hd__fill_8
XFILLER_23_233 VSS VSS VDD VDD sky130_fd_sc_hd__fill_4
XFILLER_23_237 VSS VSS VDD VDD sky130_fd_sc_hd__fill_1
XFILLER_24_0 VSS VSS VDD VDD sky130_fd_sc_hd__fill_8
XFILLER_24_8 VSS VSS VDD VDD sky130_fd_sc_hd__fill_1
XFILLER_24_19 VSS VSS VDD VDD sky130_fd_sc_hd__fill_1
XFILLER_24_40 VSS VSS VDD VDD sky130_fd_sc_hd__fill_8
XFILLER_24_48 VSS VSS VDD VDD sky130_fd_sc_hd__fill_1
XFILLER_24_52 VSS VSS VDD VDD sky130_fd_sc_hd__fill_8
XFILLER_24_60 VSS VSS VDD VDD sky130_fd_sc_hd__fill_2
XFILLER_24_62 VSS VSS VDD VDD sky130_fd_sc_hd__fill_1
XFILLER_24_67 VSS VSS VDD VDD sky130_fd_sc_hd__fill_4
XFILLER_24_71 VSS VSS VDD VDD sky130_fd_sc_hd__fill_2
XFILLER_24_73 VSS VSS VDD VDD sky130_fd_sc_hd__fill_1
XFILLER_24_80 VSS VSS VDD VDD sky130_fd_sc_hd__fill_4
XFILLER_24_84 VSS VSS VDD VDD sky130_fd_sc_hd__fill_2
XFILLER_24_86 VSS VSS VDD VDD sky130_fd_sc_hd__fill_1
XFILLER_24_91 VSS VSS VDD VDD sky130_fd_sc_hd__fill_1
XFILLER_24_96 VSS VSS VDD VDD sky130_fd_sc_hd__fill_8
XFILLER_24_104 VSS VSS VDD VDD sky130_fd_sc_hd__fill_1
XFILLER_24_108 VSS VSS VDD VDD sky130_fd_sc_hd__fill_8
XFILLER_24_116 VSS VSS VDD VDD sky130_fd_sc_hd__fill_8
XFILLER_24_124 VSS VSS VDD VDD sky130_fd_sc_hd__fill_1
XFILLER_24_128 VSS VSS VDD VDD sky130_fd_sc_hd__fill_2
XFILLER_24_130 VSS VSS VDD VDD sky130_fd_sc_hd__fill_1
XFILLER_24_137 VSS VSS VDD VDD sky130_fd_sc_hd__fill_1
XFILLER_24_141 VSS VSS VDD VDD sky130_fd_sc_hd__fill_8
XFILLER_24_149 VSS VSS VDD VDD sky130_fd_sc_hd__fill_1
XFILLER_24_151 VSS VSS VDD VDD sky130_fd_sc_hd__fill_2
XFILLER_24_162 VSS VSS VDD VDD sky130_fd_sc_hd__fill_8
XFILLER_24_170 VSS VSS VDD VDD sky130_fd_sc_hd__fill_2
XFILLER_24_197 VSS VSS VDD VDD sky130_fd_sc_hd__fill_8
XFILLER_24_205 VSS VSS VDD VDD sky130_fd_sc_hd__fill_4
XFILLER_24_209 VSS VSS VDD VDD sky130_fd_sc_hd__fill_1
XFILLER_24_211 VSS VSS VDD VDD sky130_fd_sc_hd__fill_8
XFILLER_24_219 VSS VSS VDD VDD sky130_fd_sc_hd__fill_8
XFILLER_24_227 VSS VSS VDD VDD sky130_fd_sc_hd__fill_8
XFILLER_24_235 VSS VSS VDD VDD sky130_fd_sc_hd__fill_2
XFILLER_24_237 VSS VSS VDD VDD sky130_fd_sc_hd__fill_1
XFILLER_25_0 VSS VSS VDD VDD sky130_fd_sc_hd__fill_4
XFILLER_25_4 VSS VSS VDD VDD sky130_fd_sc_hd__fill_1
XFILLER_25_37 VSS VSS VDD VDD sky130_fd_sc_hd__fill_4
XFILLER_25_41 VSS VSS VDD VDD sky130_fd_sc_hd__fill_1
XFILLER_25_49 VSS VSS VDD VDD sky130_fd_sc_hd__fill_1
XFILLER_25_59 VSS VSS VDD VDD sky130_fd_sc_hd__fill_1
XFILLER_25_78 VSS VSS VDD VDD sky130_fd_sc_hd__fill_1
XFILLER_25_82 VSS VSS VDD VDD sky130_fd_sc_hd__fill_1
XFILLER_25_87 VSS VSS VDD VDD sky130_fd_sc_hd__fill_8
XFILLER_25_95 VSS VSS VDD VDD sky130_fd_sc_hd__fill_8
XFILLER_25_103 VSS VSS VDD VDD sky130_fd_sc_hd__fill_8
XFILLER_25_111 VSS VSS VDD VDD sky130_fd_sc_hd__fill_2
XFILLER_25_116 VSS VSS VDD VDD sky130_fd_sc_hd__fill_1
XFILLER_25_124 VSS VSS VDD VDD sky130_fd_sc_hd__fill_2
XFILLER_25_138 VSS VSS VDD VDD sky130_fd_sc_hd__fill_8
XFILLER_25_146 VSS VSS VDD VDD sky130_fd_sc_hd__fill_1
XFILLER_25_157 VSS VSS VDD VDD sky130_fd_sc_hd__fill_4
XFILLER_25_170 VSS VSS VDD VDD sky130_fd_sc_hd__fill_2
XFILLER_25_178 VSS VSS VDD VDD sky130_fd_sc_hd__fill_2
XFILLER_25_181 VSS VSS VDD VDD sky130_fd_sc_hd__fill_1
XFILLER_25_195 VSS VSS VDD VDD sky130_fd_sc_hd__fill_8
XFILLER_25_203 VSS VSS VDD VDD sky130_fd_sc_hd__fill_8
XFILLER_25_211 VSS VSS VDD VDD sky130_fd_sc_hd__fill_8
XFILLER_25_219 VSS VSS VDD VDD sky130_fd_sc_hd__fill_8
XFILLER_25_227 VSS VSS VDD VDD sky130_fd_sc_hd__fill_8
XFILLER_25_235 VSS VSS VDD VDD sky130_fd_sc_hd__fill_2
XFILLER_25_237 VSS VSS VDD VDD sky130_fd_sc_hd__fill_1
XFILLER_26_0 VSS VSS VDD VDD sky130_fd_sc_hd__fill_8
XFILLER_26_8 VSS VSS VDD VDD sky130_fd_sc_hd__fill_8
XFILLER_26_16 VSS VSS VDD VDD sky130_fd_sc_hd__fill_8
XFILLER_26_24 VSS VSS VDD VDD sky130_fd_sc_hd__fill_4
XFILLER_26_28 VSS VSS VDD VDD sky130_fd_sc_hd__fill_2
XFILLER_26_31 VSS VSS VDD VDD sky130_fd_sc_hd__fill_4
XFILLER_26_35 VSS VSS VDD VDD sky130_fd_sc_hd__fill_2
XFILLER_26_64 VSS VSS VDD VDD sky130_fd_sc_hd__fill_1
XFILLER_26_70 VSS VSS VDD VDD sky130_fd_sc_hd__fill_8
XFILLER_26_98 VSS VSS VDD VDD sky130_fd_sc_hd__fill_4
XFILLER_26_121 VSS VSS VDD VDD sky130_fd_sc_hd__fill_2
XFILLER_26_136 VSS VSS VDD VDD sky130_fd_sc_hd__fill_2
XFILLER_26_144 VSS VSS VDD VDD sky130_fd_sc_hd__fill_4
XFILLER_26_148 VSS VSS VDD VDD sky130_fd_sc_hd__fill_2
XFILLER_26_154 VSS VSS VDD VDD sky130_fd_sc_hd__fill_4
XFILLER_26_158 VSS VSS VDD VDD sky130_fd_sc_hd__fill_2
XFILLER_26_160 VSS VSS VDD VDD sky130_fd_sc_hd__fill_1
XFILLER_26_180 VSS VSS VDD VDD sky130_fd_sc_hd__fill_2
XFILLER_26_198 VSS VSS VDD VDD sky130_fd_sc_hd__fill_8
XFILLER_26_206 VSS VSS VDD VDD sky130_fd_sc_hd__fill_4
XFILLER_26_211 VSS VSS VDD VDD sky130_fd_sc_hd__fill_8
XFILLER_26_219 VSS VSS VDD VDD sky130_fd_sc_hd__fill_8
XFILLER_26_227 VSS VSS VDD VDD sky130_fd_sc_hd__fill_8
XFILLER_26_235 VSS VSS VDD VDD sky130_fd_sc_hd__fill_2
XFILLER_26_237 VSS VSS VDD VDD sky130_fd_sc_hd__fill_1
XFILLER_27_0 VSS VSS VDD VDD sky130_fd_sc_hd__fill_8
XFILLER_27_8 VSS VSS VDD VDD sky130_fd_sc_hd__fill_8
XFILLER_27_16 VSS VSS VDD VDD sky130_fd_sc_hd__fill_8
XFILLER_27_24 VSS VSS VDD VDD sky130_fd_sc_hd__fill_8
XFILLER_27_32 VSS VSS VDD VDD sky130_fd_sc_hd__fill_8
XFILLER_27_40 VSS VSS VDD VDD sky130_fd_sc_hd__fill_8
XFILLER_27_48 VSS VSS VDD VDD sky130_fd_sc_hd__fill_1
XFILLER_27_64 VSS VSS VDD VDD sky130_fd_sc_hd__fill_8
XFILLER_27_72 VSS VSS VDD VDD sky130_fd_sc_hd__fill_8
XFILLER_27_80 VSS VSS VDD VDD sky130_fd_sc_hd__fill_4
XFILLER_27_98 VSS VSS VDD VDD sky130_fd_sc_hd__fill_2
XFILLER_27_100 VSS VSS VDD VDD sky130_fd_sc_hd__fill_1
XFILLER_27_104 VSS VSS VDD VDD sky130_fd_sc_hd__fill_8
XFILLER_27_112 VSS VSS VDD VDD sky130_fd_sc_hd__fill_4
XFILLER_27_116 VSS VSS VDD VDD sky130_fd_sc_hd__fill_1
XFILLER_27_121 VSS VSS VDD VDD sky130_fd_sc_hd__fill_1
XFILLER_27_138 VSS VSS VDD VDD sky130_fd_sc_hd__fill_2
XFILLER_27_140 VSS VSS VDD VDD sky130_fd_sc_hd__fill_1
XFILLER_27_157 VSS VSS VDD VDD sky130_fd_sc_hd__fill_8
XFILLER_27_165 VSS VSS VDD VDD sky130_fd_sc_hd__fill_8
XFILLER_27_173 VSS VSS VDD VDD sky130_fd_sc_hd__fill_4
XFILLER_27_177 VSS VSS VDD VDD sky130_fd_sc_hd__fill_2
XFILLER_27_179 VSS VSS VDD VDD sky130_fd_sc_hd__fill_1
XFILLER_27_181 VSS VSS VDD VDD sky130_fd_sc_hd__fill_2
XFILLER_27_189 VSS VSS VDD VDD sky130_fd_sc_hd__fill_8
XFILLER_27_197 VSS VSS VDD VDD sky130_fd_sc_hd__fill_8
XFILLER_27_205 VSS VSS VDD VDD sky130_fd_sc_hd__fill_8
XFILLER_27_213 VSS VSS VDD VDD sky130_fd_sc_hd__fill_8
XFILLER_27_221 VSS VSS VDD VDD sky130_fd_sc_hd__fill_8
XFILLER_27_229 VSS VSS VDD VDD sky130_fd_sc_hd__fill_8
XFILLER_27_237 VSS VSS VDD VDD sky130_fd_sc_hd__fill_1
XFILLER_28_0 VSS VSS VDD VDD sky130_fd_sc_hd__fill_8
XFILLER_28_8 VSS VSS VDD VDD sky130_fd_sc_hd__fill_8
XFILLER_28_16 VSS VSS VDD VDD sky130_fd_sc_hd__fill_8
XFILLER_28_24 VSS VSS VDD VDD sky130_fd_sc_hd__fill_4
XFILLER_28_28 VSS VSS VDD VDD sky130_fd_sc_hd__fill_2
XFILLER_28_31 VSS VSS VDD VDD sky130_fd_sc_hd__fill_8
XFILLER_28_39 VSS VSS VDD VDD sky130_fd_sc_hd__fill_8
XFILLER_28_47 VSS VSS VDD VDD sky130_fd_sc_hd__fill_8
XFILLER_28_55 VSS VSS VDD VDD sky130_fd_sc_hd__fill_8
XFILLER_28_63 VSS VSS VDD VDD sky130_fd_sc_hd__fill_8
XFILLER_28_71 VSS VSS VDD VDD sky130_fd_sc_hd__fill_8
XFILLER_28_79 VSS VSS VDD VDD sky130_fd_sc_hd__fill_8
XFILLER_28_91 VSS VSS VDD VDD sky130_fd_sc_hd__fill_2
XFILLER_28_125 VSS VSS VDD VDD sky130_fd_sc_hd__fill_4
XFILLER_28_129 VSS VSS VDD VDD sky130_fd_sc_hd__fill_2
XFILLER_28_134 VSS VSS VDD VDD sky130_fd_sc_hd__fill_8
XFILLER_28_142 VSS VSS VDD VDD sky130_fd_sc_hd__fill_8
XFILLER_28_151 VSS VSS VDD VDD sky130_fd_sc_hd__fill_8
XFILLER_28_159 VSS VSS VDD VDD sky130_fd_sc_hd__fill_8
XFILLER_28_167 VSS VSS VDD VDD sky130_fd_sc_hd__fill_8
XFILLER_28_175 VSS VSS VDD VDD sky130_fd_sc_hd__fill_8
XFILLER_28_183 VSS VSS VDD VDD sky130_fd_sc_hd__fill_8
XFILLER_28_191 VSS VSS VDD VDD sky130_fd_sc_hd__fill_8
XFILLER_28_199 VSS VSS VDD VDD sky130_fd_sc_hd__fill_8
XFILLER_28_207 VSS VSS VDD VDD sky130_fd_sc_hd__fill_2
XFILLER_28_209 VSS VSS VDD VDD sky130_fd_sc_hd__fill_1
XFILLER_28_211 VSS VSS VDD VDD sky130_fd_sc_hd__fill_8
XFILLER_28_219 VSS VSS VDD VDD sky130_fd_sc_hd__fill_8
XFILLER_28_227 VSS VSS VDD VDD sky130_fd_sc_hd__fill_8
XFILLER_28_235 VSS VSS VDD VDD sky130_fd_sc_hd__fill_2
XFILLER_28_237 VSS VSS VDD VDD sky130_fd_sc_hd__fill_1
XFILLER_29_0 VSS VSS VDD VDD sky130_fd_sc_hd__fill_8
XFILLER_29_8 VSS VSS VDD VDD sky130_fd_sc_hd__fill_8
XFILLER_29_16 VSS VSS VDD VDD sky130_fd_sc_hd__fill_8
XFILLER_29_24 VSS VSS VDD VDD sky130_fd_sc_hd__fill_8
XFILLER_29_32 VSS VSS VDD VDD sky130_fd_sc_hd__fill_8
XFILLER_29_40 VSS VSS VDD VDD sky130_fd_sc_hd__fill_8
XFILLER_29_48 VSS VSS VDD VDD sky130_fd_sc_hd__fill_8
XFILLER_29_56 VSS VSS VDD VDD sky130_fd_sc_hd__fill_4
XFILLER_29_61 VSS VSS VDD VDD sky130_fd_sc_hd__fill_8
XFILLER_29_69 VSS VSS VDD VDD sky130_fd_sc_hd__fill_8
XFILLER_29_77 VSS VSS VDD VDD sky130_fd_sc_hd__fill_8
XFILLER_29_85 VSS VSS VDD VDD sky130_fd_sc_hd__fill_8
XFILLER_29_93 VSS VSS VDD VDD sky130_fd_sc_hd__fill_8
XFILLER_29_101 VSS VSS VDD VDD sky130_fd_sc_hd__fill_8
XFILLER_29_109 VSS VSS VDD VDD sky130_fd_sc_hd__fill_8
XFILLER_29_117 VSS VSS VDD VDD sky130_fd_sc_hd__fill_2
XFILLER_29_119 VSS VSS VDD VDD sky130_fd_sc_hd__fill_1
XFILLER_29_121 VSS VSS VDD VDD sky130_fd_sc_hd__fill_8
XFILLER_29_129 VSS VSS VDD VDD sky130_fd_sc_hd__fill_8
XFILLER_29_137 VSS VSS VDD VDD sky130_fd_sc_hd__fill_8
XFILLER_29_145 VSS VSS VDD VDD sky130_fd_sc_hd__fill_8
XFILLER_29_153 VSS VSS VDD VDD sky130_fd_sc_hd__fill_8
XFILLER_29_161 VSS VSS VDD VDD sky130_fd_sc_hd__fill_8
XFILLER_29_169 VSS VSS VDD VDD sky130_fd_sc_hd__fill_8
XFILLER_29_177 VSS VSS VDD VDD sky130_fd_sc_hd__fill_2
XFILLER_29_179 VSS VSS VDD VDD sky130_fd_sc_hd__fill_1
XFILLER_29_181 VSS VSS VDD VDD sky130_fd_sc_hd__fill_8
XFILLER_29_189 VSS VSS VDD VDD sky130_fd_sc_hd__fill_8
XFILLER_29_197 VSS VSS VDD VDD sky130_fd_sc_hd__fill_8
XFILLER_29_205 VSS VSS VDD VDD sky130_fd_sc_hd__fill_8
XFILLER_29_213 VSS VSS VDD VDD sky130_fd_sc_hd__fill_8
XFILLER_29_221 VSS VSS VDD VDD sky130_fd_sc_hd__fill_8
XFILLER_29_229 VSS VSS VDD VDD sky130_fd_sc_hd__fill_8
XFILLER_29_237 VSS VSS VDD VDD sky130_fd_sc_hd__fill_1
XFILLER_30_0 VSS VSS VDD VDD sky130_fd_sc_hd__fill_8
XFILLER_30_8 VSS VSS VDD VDD sky130_fd_sc_hd__fill_8
XFILLER_30_16 VSS VSS VDD VDD sky130_fd_sc_hd__fill_8
XFILLER_30_24 VSS VSS VDD VDD sky130_fd_sc_hd__fill_4
XFILLER_30_28 VSS VSS VDD VDD sky130_fd_sc_hd__fill_2
XFILLER_30_31 VSS VSS VDD VDD sky130_fd_sc_hd__fill_8
XFILLER_30_39 VSS VSS VDD VDD sky130_fd_sc_hd__fill_8
XFILLER_30_47 VSS VSS VDD VDD sky130_fd_sc_hd__fill_8
XFILLER_30_55 VSS VSS VDD VDD sky130_fd_sc_hd__fill_8
XFILLER_30_63 VSS VSS VDD VDD sky130_fd_sc_hd__fill_8
XFILLER_30_71 VSS VSS VDD VDD sky130_fd_sc_hd__fill_8
XFILLER_30_79 VSS VSS VDD VDD sky130_fd_sc_hd__fill_8
XFILLER_30_87 VSS VSS VDD VDD sky130_fd_sc_hd__fill_2
XFILLER_30_89 VSS VSS VDD VDD sky130_fd_sc_hd__fill_1
XFILLER_30_91 VSS VSS VDD VDD sky130_fd_sc_hd__fill_8
XFILLER_30_99 VSS VSS VDD VDD sky130_fd_sc_hd__fill_8
XFILLER_30_107 VSS VSS VDD VDD sky130_fd_sc_hd__fill_8
XFILLER_30_115 VSS VSS VDD VDD sky130_fd_sc_hd__fill_8
XFILLER_30_123 VSS VSS VDD VDD sky130_fd_sc_hd__fill_8
XFILLER_30_131 VSS VSS VDD VDD sky130_fd_sc_hd__fill_8
XFILLER_30_139 VSS VSS VDD VDD sky130_fd_sc_hd__fill_8
XFILLER_30_147 VSS VSS VDD VDD sky130_fd_sc_hd__fill_2
XFILLER_30_149 VSS VSS VDD VDD sky130_fd_sc_hd__fill_1
XFILLER_30_151 VSS VSS VDD VDD sky130_fd_sc_hd__fill_8
XFILLER_30_159 VSS VSS VDD VDD sky130_fd_sc_hd__fill_8
XFILLER_30_167 VSS VSS VDD VDD sky130_fd_sc_hd__fill_8
XFILLER_30_175 VSS VSS VDD VDD sky130_fd_sc_hd__fill_8
XFILLER_30_183 VSS VSS VDD VDD sky130_fd_sc_hd__fill_8
XFILLER_30_191 VSS VSS VDD VDD sky130_fd_sc_hd__fill_8
XFILLER_30_199 VSS VSS VDD VDD sky130_fd_sc_hd__fill_8
XFILLER_30_207 VSS VSS VDD VDD sky130_fd_sc_hd__fill_2
XFILLER_30_209 VSS VSS VDD VDD sky130_fd_sc_hd__fill_1
XFILLER_30_211 VSS VSS VDD VDD sky130_fd_sc_hd__fill_8
XFILLER_30_219 VSS VSS VDD VDD sky130_fd_sc_hd__fill_8
XFILLER_30_227 VSS VSS VDD VDD sky130_fd_sc_hd__fill_8
XFILLER_30_235 VSS VSS VDD VDD sky130_fd_sc_hd__fill_2
XFILLER_30_237 VSS VSS VDD VDD sky130_fd_sc_hd__fill_1
XFILLER_31_0 VSS VSS VDD VDD sky130_fd_sc_hd__fill_8
XFILLER_31_8 VSS VSS VDD VDD sky130_fd_sc_hd__fill_8
XFILLER_31_16 VSS VSS VDD VDD sky130_fd_sc_hd__fill_8
XFILLER_31_24 VSS VSS VDD VDD sky130_fd_sc_hd__fill_8
XFILLER_31_32 VSS VSS VDD VDD sky130_fd_sc_hd__fill_8
XFILLER_31_40 VSS VSS VDD VDD sky130_fd_sc_hd__fill_8
XFILLER_31_48 VSS VSS VDD VDD sky130_fd_sc_hd__fill_8
XFILLER_31_56 VSS VSS VDD VDD sky130_fd_sc_hd__fill_4
XFILLER_31_61 VSS VSS VDD VDD sky130_fd_sc_hd__fill_8
XFILLER_31_69 VSS VSS VDD VDD sky130_fd_sc_hd__fill_8
XFILLER_31_77 VSS VSS VDD VDD sky130_fd_sc_hd__fill_8
XFILLER_31_85 VSS VSS VDD VDD sky130_fd_sc_hd__fill_8
XFILLER_31_93 VSS VSS VDD VDD sky130_fd_sc_hd__fill_8
XFILLER_31_101 VSS VSS VDD VDD sky130_fd_sc_hd__fill_8
XFILLER_31_109 VSS VSS VDD VDD sky130_fd_sc_hd__fill_8
XFILLER_31_117 VSS VSS VDD VDD sky130_fd_sc_hd__fill_2
XFILLER_31_119 VSS VSS VDD VDD sky130_fd_sc_hd__fill_1
XFILLER_31_121 VSS VSS VDD VDD sky130_fd_sc_hd__fill_8
XFILLER_31_129 VSS VSS VDD VDD sky130_fd_sc_hd__fill_8
XFILLER_31_137 VSS VSS VDD VDD sky130_fd_sc_hd__fill_8
XFILLER_31_145 VSS VSS VDD VDD sky130_fd_sc_hd__fill_8
XFILLER_31_153 VSS VSS VDD VDD sky130_fd_sc_hd__fill_8
XFILLER_31_161 VSS VSS VDD VDD sky130_fd_sc_hd__fill_8
XFILLER_31_169 VSS VSS VDD VDD sky130_fd_sc_hd__fill_8
XFILLER_31_177 VSS VSS VDD VDD sky130_fd_sc_hd__fill_2
XFILLER_31_179 VSS VSS VDD VDD sky130_fd_sc_hd__fill_1
XFILLER_31_181 VSS VSS VDD VDD sky130_fd_sc_hd__fill_8
XFILLER_31_189 VSS VSS VDD VDD sky130_fd_sc_hd__fill_8
XFILLER_31_197 VSS VSS VDD VDD sky130_fd_sc_hd__fill_8
XFILLER_31_205 VSS VSS VDD VDD sky130_fd_sc_hd__fill_8
XFILLER_31_213 VSS VSS VDD VDD sky130_fd_sc_hd__fill_8
XFILLER_31_221 VSS VSS VDD VDD sky130_fd_sc_hd__fill_8
XFILLER_31_229 VSS VSS VDD VDD sky130_fd_sc_hd__fill_8
XFILLER_31_237 VSS VSS VDD VDD sky130_fd_sc_hd__fill_1
XFILLER_32_0 VSS VSS VDD VDD sky130_fd_sc_hd__fill_8
XFILLER_32_8 VSS VSS VDD VDD sky130_fd_sc_hd__fill_8
XFILLER_32_16 VSS VSS VDD VDD sky130_fd_sc_hd__fill_8
XFILLER_32_24 VSS VSS VDD VDD sky130_fd_sc_hd__fill_4
XFILLER_32_28 VSS VSS VDD VDD sky130_fd_sc_hd__fill_2
XFILLER_32_31 VSS VSS VDD VDD sky130_fd_sc_hd__fill_8
XFILLER_32_39 VSS VSS VDD VDD sky130_fd_sc_hd__fill_8
XFILLER_32_47 VSS VSS VDD VDD sky130_fd_sc_hd__fill_8
XFILLER_32_55 VSS VSS VDD VDD sky130_fd_sc_hd__fill_8
XFILLER_32_63 VSS VSS VDD VDD sky130_fd_sc_hd__fill_8
XFILLER_32_71 VSS VSS VDD VDD sky130_fd_sc_hd__fill_8
XFILLER_32_79 VSS VSS VDD VDD sky130_fd_sc_hd__fill_8
XFILLER_32_87 VSS VSS VDD VDD sky130_fd_sc_hd__fill_2
XFILLER_32_89 VSS VSS VDD VDD sky130_fd_sc_hd__fill_1
XFILLER_32_91 VSS VSS VDD VDD sky130_fd_sc_hd__fill_8
XFILLER_32_99 VSS VSS VDD VDD sky130_fd_sc_hd__fill_8
XFILLER_32_107 VSS VSS VDD VDD sky130_fd_sc_hd__fill_8
XFILLER_32_115 VSS VSS VDD VDD sky130_fd_sc_hd__fill_8
XFILLER_32_123 VSS VSS VDD VDD sky130_fd_sc_hd__fill_8
XFILLER_32_131 VSS VSS VDD VDD sky130_fd_sc_hd__fill_8
XFILLER_32_139 VSS VSS VDD VDD sky130_fd_sc_hd__fill_8
XFILLER_32_147 VSS VSS VDD VDD sky130_fd_sc_hd__fill_2
XFILLER_32_149 VSS VSS VDD VDD sky130_fd_sc_hd__fill_1
XFILLER_32_151 VSS VSS VDD VDD sky130_fd_sc_hd__fill_8
XFILLER_32_159 VSS VSS VDD VDD sky130_fd_sc_hd__fill_8
XFILLER_32_167 VSS VSS VDD VDD sky130_fd_sc_hd__fill_8
XFILLER_32_175 VSS VSS VDD VDD sky130_fd_sc_hd__fill_8
XFILLER_32_183 VSS VSS VDD VDD sky130_fd_sc_hd__fill_8
XFILLER_32_191 VSS VSS VDD VDD sky130_fd_sc_hd__fill_8
XFILLER_32_199 VSS VSS VDD VDD sky130_fd_sc_hd__fill_8
XFILLER_32_207 VSS VSS VDD VDD sky130_fd_sc_hd__fill_2
XFILLER_32_209 VSS VSS VDD VDD sky130_fd_sc_hd__fill_1
XFILLER_32_211 VSS VSS VDD VDD sky130_fd_sc_hd__fill_8
XFILLER_32_219 VSS VSS VDD VDD sky130_fd_sc_hd__fill_8
XFILLER_32_227 VSS VSS VDD VDD sky130_fd_sc_hd__fill_8
XFILLER_32_235 VSS VSS VDD VDD sky130_fd_sc_hd__fill_2
XFILLER_32_237 VSS VSS VDD VDD sky130_fd_sc_hd__fill_1
XFILLER_33_0 VSS VSS VDD VDD sky130_fd_sc_hd__fill_8
XFILLER_33_8 VSS VSS VDD VDD sky130_fd_sc_hd__fill_8
XFILLER_33_16 VSS VSS VDD VDD sky130_fd_sc_hd__fill_8
XFILLER_33_24 VSS VSS VDD VDD sky130_fd_sc_hd__fill_8
XFILLER_33_32 VSS VSS VDD VDD sky130_fd_sc_hd__fill_8
XFILLER_33_40 VSS VSS VDD VDD sky130_fd_sc_hd__fill_8
XFILLER_33_48 VSS VSS VDD VDD sky130_fd_sc_hd__fill_8
XFILLER_33_56 VSS VSS VDD VDD sky130_fd_sc_hd__fill_4
XFILLER_33_61 VSS VSS VDD VDD sky130_fd_sc_hd__fill_8
XFILLER_33_69 VSS VSS VDD VDD sky130_fd_sc_hd__fill_8
XFILLER_33_77 VSS VSS VDD VDD sky130_fd_sc_hd__fill_8
XFILLER_33_85 VSS VSS VDD VDD sky130_fd_sc_hd__fill_8
XFILLER_33_93 VSS VSS VDD VDD sky130_fd_sc_hd__fill_8
XFILLER_33_101 VSS VSS VDD VDD sky130_fd_sc_hd__fill_8
XFILLER_33_109 VSS VSS VDD VDD sky130_fd_sc_hd__fill_8
XFILLER_33_117 VSS VSS VDD VDD sky130_fd_sc_hd__fill_2
XFILLER_33_119 VSS VSS VDD VDD sky130_fd_sc_hd__fill_1
XFILLER_33_121 VSS VSS VDD VDD sky130_fd_sc_hd__fill_8
XFILLER_33_129 VSS VSS VDD VDD sky130_fd_sc_hd__fill_8
XFILLER_33_137 VSS VSS VDD VDD sky130_fd_sc_hd__fill_8
XFILLER_33_145 VSS VSS VDD VDD sky130_fd_sc_hd__fill_8
XFILLER_33_153 VSS VSS VDD VDD sky130_fd_sc_hd__fill_8
XFILLER_33_161 VSS VSS VDD VDD sky130_fd_sc_hd__fill_8
XFILLER_33_169 VSS VSS VDD VDD sky130_fd_sc_hd__fill_8
XFILLER_33_177 VSS VSS VDD VDD sky130_fd_sc_hd__fill_2
XFILLER_33_179 VSS VSS VDD VDD sky130_fd_sc_hd__fill_1
XFILLER_33_181 VSS VSS VDD VDD sky130_fd_sc_hd__fill_8
XFILLER_33_189 VSS VSS VDD VDD sky130_fd_sc_hd__fill_8
XFILLER_33_197 VSS VSS VDD VDD sky130_fd_sc_hd__fill_8
XFILLER_33_205 VSS VSS VDD VDD sky130_fd_sc_hd__fill_8
XFILLER_33_213 VSS VSS VDD VDD sky130_fd_sc_hd__fill_8
XFILLER_33_221 VSS VSS VDD VDD sky130_fd_sc_hd__fill_8
XFILLER_33_229 VSS VSS VDD VDD sky130_fd_sc_hd__fill_8
XFILLER_33_237 VSS VSS VDD VDD sky130_fd_sc_hd__fill_1
XFILLER_34_0 VSS VSS VDD VDD sky130_fd_sc_hd__fill_8
XFILLER_34_8 VSS VSS VDD VDD sky130_fd_sc_hd__fill_8
XFILLER_34_16 VSS VSS VDD VDD sky130_fd_sc_hd__fill_8
XFILLER_34_24 VSS VSS VDD VDD sky130_fd_sc_hd__fill_4
XFILLER_34_28 VSS VSS VDD VDD sky130_fd_sc_hd__fill_2
XFILLER_34_31 VSS VSS VDD VDD sky130_fd_sc_hd__fill_8
XFILLER_34_39 VSS VSS VDD VDD sky130_fd_sc_hd__fill_8
XFILLER_34_47 VSS VSS VDD VDD sky130_fd_sc_hd__fill_8
XFILLER_34_55 VSS VSS VDD VDD sky130_fd_sc_hd__fill_8
XFILLER_34_63 VSS VSS VDD VDD sky130_fd_sc_hd__fill_8
XFILLER_34_71 VSS VSS VDD VDD sky130_fd_sc_hd__fill_8
XFILLER_34_79 VSS VSS VDD VDD sky130_fd_sc_hd__fill_8
XFILLER_34_87 VSS VSS VDD VDD sky130_fd_sc_hd__fill_2
XFILLER_34_89 VSS VSS VDD VDD sky130_fd_sc_hd__fill_1
XFILLER_34_91 VSS VSS VDD VDD sky130_fd_sc_hd__fill_8
XFILLER_34_99 VSS VSS VDD VDD sky130_fd_sc_hd__fill_8
XFILLER_34_107 VSS VSS VDD VDD sky130_fd_sc_hd__fill_8
XFILLER_34_115 VSS VSS VDD VDD sky130_fd_sc_hd__fill_8
XFILLER_34_123 VSS VSS VDD VDD sky130_fd_sc_hd__fill_8
XFILLER_34_131 VSS VSS VDD VDD sky130_fd_sc_hd__fill_8
XFILLER_34_139 VSS VSS VDD VDD sky130_fd_sc_hd__fill_8
XFILLER_34_147 VSS VSS VDD VDD sky130_fd_sc_hd__fill_2
XFILLER_34_149 VSS VSS VDD VDD sky130_fd_sc_hd__fill_1
XFILLER_34_151 VSS VSS VDD VDD sky130_fd_sc_hd__fill_8
XFILLER_34_159 VSS VSS VDD VDD sky130_fd_sc_hd__fill_8
XFILLER_34_167 VSS VSS VDD VDD sky130_fd_sc_hd__fill_8
XFILLER_34_175 VSS VSS VDD VDD sky130_fd_sc_hd__fill_8
XFILLER_34_183 VSS VSS VDD VDD sky130_fd_sc_hd__fill_8
XFILLER_34_191 VSS VSS VDD VDD sky130_fd_sc_hd__fill_8
XFILLER_34_199 VSS VSS VDD VDD sky130_fd_sc_hd__fill_8
XFILLER_34_207 VSS VSS VDD VDD sky130_fd_sc_hd__fill_2
XFILLER_34_209 VSS VSS VDD VDD sky130_fd_sc_hd__fill_1
XFILLER_34_211 VSS VSS VDD VDD sky130_fd_sc_hd__fill_8
XFILLER_34_219 VSS VSS VDD VDD sky130_fd_sc_hd__fill_8
XFILLER_34_227 VSS VSS VDD VDD sky130_fd_sc_hd__fill_8
XFILLER_34_235 VSS VSS VDD VDD sky130_fd_sc_hd__fill_2
XFILLER_34_237 VSS VSS VDD VDD sky130_fd_sc_hd__fill_1
XFILLER_35_0 VSS VSS VDD VDD sky130_fd_sc_hd__fill_8
XFILLER_35_8 VSS VSS VDD VDD sky130_fd_sc_hd__fill_8
XFILLER_35_16 VSS VSS VDD VDD sky130_fd_sc_hd__fill_8
XFILLER_35_24 VSS VSS VDD VDD sky130_fd_sc_hd__fill_8
XFILLER_35_32 VSS VSS VDD VDD sky130_fd_sc_hd__fill_8
XFILLER_35_40 VSS VSS VDD VDD sky130_fd_sc_hd__fill_8
XFILLER_35_48 VSS VSS VDD VDD sky130_fd_sc_hd__fill_8
XFILLER_35_56 VSS VSS VDD VDD sky130_fd_sc_hd__fill_4
XFILLER_35_61 VSS VSS VDD VDD sky130_fd_sc_hd__fill_8
XFILLER_35_69 VSS VSS VDD VDD sky130_fd_sc_hd__fill_8
XFILLER_35_77 VSS VSS VDD VDD sky130_fd_sc_hd__fill_8
XFILLER_35_85 VSS VSS VDD VDD sky130_fd_sc_hd__fill_8
XFILLER_35_93 VSS VSS VDD VDD sky130_fd_sc_hd__fill_8
XFILLER_35_101 VSS VSS VDD VDD sky130_fd_sc_hd__fill_8
XFILLER_35_109 VSS VSS VDD VDD sky130_fd_sc_hd__fill_8
XFILLER_35_117 VSS VSS VDD VDD sky130_fd_sc_hd__fill_2
XFILLER_35_119 VSS VSS VDD VDD sky130_fd_sc_hd__fill_1
XFILLER_35_121 VSS VSS VDD VDD sky130_fd_sc_hd__fill_8
XFILLER_35_129 VSS VSS VDD VDD sky130_fd_sc_hd__fill_8
XFILLER_35_137 VSS VSS VDD VDD sky130_fd_sc_hd__fill_8
XFILLER_35_145 VSS VSS VDD VDD sky130_fd_sc_hd__fill_8
XFILLER_35_153 VSS VSS VDD VDD sky130_fd_sc_hd__fill_8
XFILLER_35_161 VSS VSS VDD VDD sky130_fd_sc_hd__fill_8
XFILLER_35_169 VSS VSS VDD VDD sky130_fd_sc_hd__fill_8
XFILLER_35_177 VSS VSS VDD VDD sky130_fd_sc_hd__fill_2
XFILLER_35_179 VSS VSS VDD VDD sky130_fd_sc_hd__fill_1
XFILLER_35_181 VSS VSS VDD VDD sky130_fd_sc_hd__fill_8
XFILLER_35_189 VSS VSS VDD VDD sky130_fd_sc_hd__fill_8
XFILLER_35_197 VSS VSS VDD VDD sky130_fd_sc_hd__fill_8
XFILLER_35_205 VSS VSS VDD VDD sky130_fd_sc_hd__fill_8
XFILLER_35_213 VSS VSS VDD VDD sky130_fd_sc_hd__fill_8
XFILLER_35_221 VSS VSS VDD VDD sky130_fd_sc_hd__fill_8
XFILLER_35_229 VSS VSS VDD VDD sky130_fd_sc_hd__fill_8
XFILLER_35_237 VSS VSS VDD VDD sky130_fd_sc_hd__fill_1
XFILLER_36_0 VSS VSS VDD VDD sky130_fd_sc_hd__fill_8
XFILLER_36_8 VSS VSS VDD VDD sky130_fd_sc_hd__fill_8
XFILLER_36_16 VSS VSS VDD VDD sky130_fd_sc_hd__fill_8
XFILLER_36_24 VSS VSS VDD VDD sky130_fd_sc_hd__fill_4
XFILLER_36_28 VSS VSS VDD VDD sky130_fd_sc_hd__fill_2
XFILLER_36_31 VSS VSS VDD VDD sky130_fd_sc_hd__fill_8
XFILLER_36_39 VSS VSS VDD VDD sky130_fd_sc_hd__fill_8
XFILLER_36_47 VSS VSS VDD VDD sky130_fd_sc_hd__fill_8
XFILLER_36_55 VSS VSS VDD VDD sky130_fd_sc_hd__fill_8
XFILLER_36_63 VSS VSS VDD VDD sky130_fd_sc_hd__fill_8
XFILLER_36_71 VSS VSS VDD VDD sky130_fd_sc_hd__fill_8
XFILLER_36_79 VSS VSS VDD VDD sky130_fd_sc_hd__fill_8
XFILLER_36_87 VSS VSS VDD VDD sky130_fd_sc_hd__fill_2
XFILLER_36_89 VSS VSS VDD VDD sky130_fd_sc_hd__fill_1
XFILLER_36_91 VSS VSS VDD VDD sky130_fd_sc_hd__fill_8
XFILLER_36_99 VSS VSS VDD VDD sky130_fd_sc_hd__fill_8
XFILLER_36_107 VSS VSS VDD VDD sky130_fd_sc_hd__fill_8
XFILLER_36_115 VSS VSS VDD VDD sky130_fd_sc_hd__fill_8
XFILLER_36_123 VSS VSS VDD VDD sky130_fd_sc_hd__fill_8
XFILLER_36_131 VSS VSS VDD VDD sky130_fd_sc_hd__fill_8
XFILLER_36_139 VSS VSS VDD VDD sky130_fd_sc_hd__fill_8
XFILLER_36_147 VSS VSS VDD VDD sky130_fd_sc_hd__fill_2
XFILLER_36_149 VSS VSS VDD VDD sky130_fd_sc_hd__fill_1
XFILLER_36_151 VSS VSS VDD VDD sky130_fd_sc_hd__fill_8
XFILLER_36_159 VSS VSS VDD VDD sky130_fd_sc_hd__fill_8
XFILLER_36_167 VSS VSS VDD VDD sky130_fd_sc_hd__fill_8
XFILLER_36_175 VSS VSS VDD VDD sky130_fd_sc_hd__fill_8
XFILLER_36_183 VSS VSS VDD VDD sky130_fd_sc_hd__fill_8
XFILLER_36_191 VSS VSS VDD VDD sky130_fd_sc_hd__fill_8
XFILLER_36_199 VSS VSS VDD VDD sky130_fd_sc_hd__fill_8
XFILLER_36_207 VSS VSS VDD VDD sky130_fd_sc_hd__fill_2
XFILLER_36_209 VSS VSS VDD VDD sky130_fd_sc_hd__fill_1
XFILLER_36_211 VSS VSS VDD VDD sky130_fd_sc_hd__fill_8
XFILLER_36_219 VSS VSS VDD VDD sky130_fd_sc_hd__fill_8
XFILLER_36_227 VSS VSS VDD VDD sky130_fd_sc_hd__fill_8
XFILLER_36_235 VSS VSS VDD VDD sky130_fd_sc_hd__fill_2
XFILLER_36_237 VSS VSS VDD VDD sky130_fd_sc_hd__fill_1
XFILLER_37_0 VSS VSS VDD VDD sky130_fd_sc_hd__fill_8
XFILLER_37_8 VSS VSS VDD VDD sky130_fd_sc_hd__fill_8
XFILLER_37_16 VSS VSS VDD VDD sky130_fd_sc_hd__fill_8
XFILLER_37_24 VSS VSS VDD VDD sky130_fd_sc_hd__fill_8
XFILLER_37_32 VSS VSS VDD VDD sky130_fd_sc_hd__fill_8
XFILLER_37_40 VSS VSS VDD VDD sky130_fd_sc_hd__fill_8
XFILLER_37_48 VSS VSS VDD VDD sky130_fd_sc_hd__fill_8
XFILLER_37_56 VSS VSS VDD VDD sky130_fd_sc_hd__fill_4
XFILLER_37_61 VSS VSS VDD VDD sky130_fd_sc_hd__fill_8
XFILLER_37_69 VSS VSS VDD VDD sky130_fd_sc_hd__fill_8
XFILLER_37_77 VSS VSS VDD VDD sky130_fd_sc_hd__fill_8
XFILLER_37_85 VSS VSS VDD VDD sky130_fd_sc_hd__fill_8
XFILLER_37_93 VSS VSS VDD VDD sky130_fd_sc_hd__fill_8
XFILLER_37_101 VSS VSS VDD VDD sky130_fd_sc_hd__fill_8
XFILLER_37_109 VSS VSS VDD VDD sky130_fd_sc_hd__fill_8
XFILLER_37_117 VSS VSS VDD VDD sky130_fd_sc_hd__fill_2
XFILLER_37_119 VSS VSS VDD VDD sky130_fd_sc_hd__fill_1
XFILLER_37_121 VSS VSS VDD VDD sky130_fd_sc_hd__fill_8
XFILLER_37_129 VSS VSS VDD VDD sky130_fd_sc_hd__fill_8
XFILLER_37_137 VSS VSS VDD VDD sky130_fd_sc_hd__fill_8
XFILLER_37_145 VSS VSS VDD VDD sky130_fd_sc_hd__fill_8
XFILLER_37_153 VSS VSS VDD VDD sky130_fd_sc_hd__fill_8
XFILLER_37_161 VSS VSS VDD VDD sky130_fd_sc_hd__fill_8
XFILLER_37_169 VSS VSS VDD VDD sky130_fd_sc_hd__fill_8
XFILLER_37_177 VSS VSS VDD VDD sky130_fd_sc_hd__fill_2
XFILLER_37_179 VSS VSS VDD VDD sky130_fd_sc_hd__fill_1
XFILLER_37_181 VSS VSS VDD VDD sky130_fd_sc_hd__fill_8
XFILLER_37_189 VSS VSS VDD VDD sky130_fd_sc_hd__fill_8
XFILLER_37_197 VSS VSS VDD VDD sky130_fd_sc_hd__fill_8
XFILLER_37_205 VSS VSS VDD VDD sky130_fd_sc_hd__fill_8
XFILLER_37_213 VSS VSS VDD VDD sky130_fd_sc_hd__fill_8
XFILLER_37_221 VSS VSS VDD VDD sky130_fd_sc_hd__fill_8
XFILLER_37_229 VSS VSS VDD VDD sky130_fd_sc_hd__fill_8
XFILLER_37_237 VSS VSS VDD VDD sky130_fd_sc_hd__fill_1
XFILLER_38_0 VSS VSS VDD VDD sky130_fd_sc_hd__fill_8
XFILLER_38_8 VSS VSS VDD VDD sky130_fd_sc_hd__fill_8
XFILLER_38_16 VSS VSS VDD VDD sky130_fd_sc_hd__fill_8
XFILLER_38_24 VSS VSS VDD VDD sky130_fd_sc_hd__fill_4
XFILLER_38_28 VSS VSS VDD VDD sky130_fd_sc_hd__fill_2
XFILLER_38_31 VSS VSS VDD VDD sky130_fd_sc_hd__fill_8
XFILLER_38_39 VSS VSS VDD VDD sky130_fd_sc_hd__fill_8
XFILLER_38_47 VSS VSS VDD VDD sky130_fd_sc_hd__fill_8
XFILLER_38_55 VSS VSS VDD VDD sky130_fd_sc_hd__fill_8
XFILLER_38_63 VSS VSS VDD VDD sky130_fd_sc_hd__fill_8
XFILLER_38_71 VSS VSS VDD VDD sky130_fd_sc_hd__fill_8
XFILLER_38_79 VSS VSS VDD VDD sky130_fd_sc_hd__fill_8
XFILLER_38_87 VSS VSS VDD VDD sky130_fd_sc_hd__fill_2
XFILLER_38_89 VSS VSS VDD VDD sky130_fd_sc_hd__fill_1
XFILLER_38_91 VSS VSS VDD VDD sky130_fd_sc_hd__fill_8
XFILLER_38_99 VSS VSS VDD VDD sky130_fd_sc_hd__fill_8
XFILLER_38_107 VSS VSS VDD VDD sky130_fd_sc_hd__fill_8
XFILLER_38_115 VSS VSS VDD VDD sky130_fd_sc_hd__fill_8
XFILLER_38_123 VSS VSS VDD VDD sky130_fd_sc_hd__fill_8
XFILLER_38_131 VSS VSS VDD VDD sky130_fd_sc_hd__fill_8
XFILLER_38_139 VSS VSS VDD VDD sky130_fd_sc_hd__fill_8
XFILLER_38_147 VSS VSS VDD VDD sky130_fd_sc_hd__fill_2
XFILLER_38_149 VSS VSS VDD VDD sky130_fd_sc_hd__fill_1
XFILLER_38_151 VSS VSS VDD VDD sky130_fd_sc_hd__fill_8
XFILLER_38_159 VSS VSS VDD VDD sky130_fd_sc_hd__fill_8
XFILLER_38_167 VSS VSS VDD VDD sky130_fd_sc_hd__fill_8
XFILLER_38_175 VSS VSS VDD VDD sky130_fd_sc_hd__fill_8
XFILLER_38_183 VSS VSS VDD VDD sky130_fd_sc_hd__fill_8
XFILLER_38_191 VSS VSS VDD VDD sky130_fd_sc_hd__fill_8
XFILLER_38_199 VSS VSS VDD VDD sky130_fd_sc_hd__fill_8
XFILLER_38_207 VSS VSS VDD VDD sky130_fd_sc_hd__fill_2
XFILLER_38_209 VSS VSS VDD VDD sky130_fd_sc_hd__fill_1
XFILLER_38_211 VSS VSS VDD VDD sky130_fd_sc_hd__fill_8
XFILLER_38_219 VSS VSS VDD VDD sky130_fd_sc_hd__fill_8
XFILLER_38_227 VSS VSS VDD VDD sky130_fd_sc_hd__fill_8
XFILLER_38_235 VSS VSS VDD VDD sky130_fd_sc_hd__fill_2
XFILLER_38_237 VSS VSS VDD VDD sky130_fd_sc_hd__fill_1
XFILLER_39_0 VSS VSS VDD VDD sky130_fd_sc_hd__fill_8
XFILLER_39_8 VSS VSS VDD VDD sky130_fd_sc_hd__fill_8
XFILLER_39_16 VSS VSS VDD VDD sky130_fd_sc_hd__fill_8
XFILLER_39_24 VSS VSS VDD VDD sky130_fd_sc_hd__fill_4
XFILLER_39_28 VSS VSS VDD VDD sky130_fd_sc_hd__fill_2
XFILLER_39_31 VSS VSS VDD VDD sky130_fd_sc_hd__fill_8
XFILLER_39_39 VSS VSS VDD VDD sky130_fd_sc_hd__fill_8
XFILLER_39_47 VSS VSS VDD VDD sky130_fd_sc_hd__fill_8
XFILLER_39_55 VSS VSS VDD VDD sky130_fd_sc_hd__fill_4
XFILLER_39_59 VSS VSS VDD VDD sky130_fd_sc_hd__fill_1
XFILLER_39_61 VSS VSS VDD VDD sky130_fd_sc_hd__fill_8
XFILLER_39_69 VSS VSS VDD VDD sky130_fd_sc_hd__fill_8
XFILLER_39_77 VSS VSS VDD VDD sky130_fd_sc_hd__fill_8
XFILLER_39_85 VSS VSS VDD VDD sky130_fd_sc_hd__fill_4
XFILLER_39_89 VSS VSS VDD VDD sky130_fd_sc_hd__fill_1
XFILLER_39_91 VSS VSS VDD VDD sky130_fd_sc_hd__fill_8
XFILLER_39_99 VSS VSS VDD VDD sky130_fd_sc_hd__fill_8
XFILLER_39_107 VSS VSS VDD VDD sky130_fd_sc_hd__fill_8
XFILLER_39_115 VSS VSS VDD VDD sky130_fd_sc_hd__fill_4
XFILLER_39_119 VSS VSS VDD VDD sky130_fd_sc_hd__fill_1
XFILLER_39_121 VSS VSS VDD VDD sky130_fd_sc_hd__fill_8
XFILLER_39_129 VSS VSS VDD VDD sky130_fd_sc_hd__fill_8
XFILLER_39_137 VSS VSS VDD VDD sky130_fd_sc_hd__fill_8
XFILLER_39_145 VSS VSS VDD VDD sky130_fd_sc_hd__fill_4
XFILLER_39_149 VSS VSS VDD VDD sky130_fd_sc_hd__fill_1
XFILLER_39_151 VSS VSS VDD VDD sky130_fd_sc_hd__fill_8
XFILLER_39_159 VSS VSS VDD VDD sky130_fd_sc_hd__fill_8
XFILLER_39_167 VSS VSS VDD VDD sky130_fd_sc_hd__fill_8
XFILLER_39_175 VSS VSS VDD VDD sky130_fd_sc_hd__fill_4
XFILLER_39_179 VSS VSS VDD VDD sky130_fd_sc_hd__fill_1
XFILLER_39_181 VSS VSS VDD VDD sky130_fd_sc_hd__fill_8
XFILLER_39_189 VSS VSS VDD VDD sky130_fd_sc_hd__fill_8
XFILLER_39_197 VSS VSS VDD VDD sky130_fd_sc_hd__fill_8
XFILLER_39_205 VSS VSS VDD VDD sky130_fd_sc_hd__fill_4
XFILLER_39_209 VSS VSS VDD VDD sky130_fd_sc_hd__fill_1
XFILLER_39_211 VSS VSS VDD VDD sky130_fd_sc_hd__fill_8
XFILLER_39_219 VSS VSS VDD VDD sky130_fd_sc_hd__fill_8
XFILLER_39_227 VSS VSS VDD VDD sky130_fd_sc_hd__fill_8
XFILLER_39_235 VSS VSS VDD VDD sky130_fd_sc_hd__fill_2
XFILLER_39_237 VSS VSS VDD VDD sky130_fd_sc_hd__fill_1
.ENDS axis_eth_fcs_reset
